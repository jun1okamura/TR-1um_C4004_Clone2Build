* Post-Layout Extracted Netlist of OSS_FRAME prepared for ngspice
.SUBCKT OSS_FRAME P1 P10 P11 P12 P13 P14 P15 P2 P3 P4 P5 P6 P7 P9 VDD VSS
X_d_3 P10 VDD VDD VSS VSS OSS_ESD_5V_DIO
X_d_4 P1 VDD VDD VSS VSS OSS_ESD_5V_DIO
X_d_5 P7 VDD VDD VSS VSS OSS_ESD_5V_DIO
X_d_6 VDD P7 _n_I41 P10 _n_I23 _n_I36 _n_I29 P6 _n_I32 _n_I30 _n_I40 _n_I39 P5 _n_I33 _n_I37 P4 _n_I34 P3 _n_I35 P1 VSS c4004_core
X_d_7 P12 VDD VSS _n_I40 VSS OSS_ESD_5V_DIO
X_d_8 P14 VDD VSS _n_I39 VSS OSS_ESD_5V_DIO
X_d_9 P9 VDD VSS _n_I41 VSS OSS_ESD_5V_DIO
X_d_10 VDD VSS OSS_ESD_5V_VSS
X_d_11 P4 VDD _n_I23 _n_I37 VSS OSS_ESD_5V_DIO
X_d_12 P6 VDD _n_I23 _n_I36 VSS OSS_ESD_5V_DIO
X_d_13 P2 VDD VSS _n_I35 VSS OSS_ESD_5V_DIO
X_d_14 P3 VDD _n_I23 _n_I34 VSS OSS_ESD_5V_DIO
X_d_15 P5 VDD _n_I23 _n_I33 VSS OSS_ESD_5V_DIO
X_d_16 P15 VDD VSS _n_I32 VSS OSS_ESD_5V_DIO
X_d_17 VDD VSS OSS_ESD_5V_VDD
X_d_18 P13 VDD VSS _n_I30 VSS OSS_ESD_5V_DIO
X_d_19 P11 VDD VSS _n_I29 VSS OSS_ESD_5V_DIO
.ENDS OSS_FRAME
.SUBCKT c4004_core _n_4 _n_10 _n_15 _n_17 _n_43 _n_152 _n_158 _n_183 _n_201 _n_205 _n_241 _n_275 _n_313 _n_334 _n_471 _n_495 _n_532 _n_579 _n_581 _n_632 VSS
X_d_1 _n_4 _n_657 _n_659 _n_618 _n_645 _n_655 _n_661 _n_654 _n_662 _n_359 _n_658 _n_383 _n_653 _n_425 _n_652 _n_376 VSS SRAM128
X_d_2 _n_372 _n_477 _n_408 _n_451 _n_4 VSS MUX2
X_d_3 _n_372 _n_382 _n_362 _n_351 _n_4 VSS MUX2
X_d_4 _n_369 _n_543 _n_408 _n_467 _n_4 VSS MUX2
X_d_5 _n_369 _n_429 _n_280 _n_335 _n_4 VSS MUX2
X_d_6 _n_372 _n_308 _n_408 _n_439 _n_4 VSS MUX2
X_d_7 _n_194 _n_237 _n_238 _n_240 _n_4 VSS MUX2
X_d_8 _n_144 _n_237 _n_238 _n_272 _n_4 VSS MUX2
X_d_9 _n_369 _n_580 _n_510 _n_527 _n_4 VSS MUX2
X_d_10 _n_372 _n_508 _n_510 _n_479 _n_4 VSS MUX2
X_d_11 _n_372 _n_360 _n_510 _n_505 _n_4 VSS MUX2
X_d_12 _n_372 _n_410 _n_280 _n_353 _n_4 VSS MUX2
X_d_13 _n_372 _n_328 _n_280 _n_320 _n_4 VSS MUX2
X_d_14 _n_369 _n_541 _n_362 _n_370 _n_4 VSS MUX2
X_d_15 _n_372 _n_385 _n_362 _n_394 _n_4 VSS MUX2
X_d_16 _n_326 _n_518 _n_519 _n_484 _n_525 _n_4 VSS AND4_X1
X_d_17 _n_555 _n_472 _n_490 _n_483 _n_516 _n_4 VSS AND4_X1
X_d_18 _n_427 _n_418 _n_317 _n_453 _n_4 VSS OR3
X_d_19 _n_545 _n_488 _n_480 _n_573 _n_4 VSS OR3
X_d_20 _n_545 _n_489 _n_473 _n_561 _n_4 VSS OR3
X_d_21 _n_452 _n_489 _n_488 _n_537 _n_4 VSS OR3
X_d_22 _n_545 _n_489 _n_488 _n_539 _n_4 VSS OR3
X_d_23 _n_242 _n_217 _n_179 _n_163 _n_4 VSS OR3
X_d_24 _n_96 _n_51 _n_137 _n_147 _n_77 _n_4 VSS OR4
X_d_25 _n_317 _n_346 _n_209 _n_358 _n_304 _n_4 VSS OR4
X_d_26 _n_298 _n_346 _n_311 _n_358 _n_345 _n_4 VSS OR4
X_d_27 _n_94 _n_51 _n_95 _n_92 _n_96 _n_4 VSS OR4
X_d_28 _n_346 _n_347 _n_177 _n_345 _n_298 _n_4 VSS OR4
X_d_29 _n_346 _n_347 _n_487 _n_304 _n_298 _n_4 VSS OR4
X_d_30 _n_187 _n_188 _n_315 _n_285 _n_4 _n_234 VSS OAI22
X_d_31 _n_485 _n_330 _n_403 _n_78 _n_4 _n_461 VSS OAI22
X_d_32 _n_440 _n_482 _n_491 _n_537 _n_4 _n_515 VSS OAI22
X_d_33 _n_586 _n_610 _n_638 _n_608 _n_4 _n_654 VSS OAI22
X_d_34 _n_522 _n_399 _n_535 _n_561 _n_4 _n_563 VSS OAI22
X_d_35 _n_639 _n_640 _n_638 _n_608 _n_4 _n_655 VSS OAI22
X_d_36 _n_568 _n_540 _n_550 _n_337 _n_4 _n_557 VSS OAI22
X_d_37 _n_249 _n_230 _n_270 _n_225 _n_4 _n_220 VSS OAI22
X_d_38 _n_565 _n_522 _n_517 _n_540 _n_4 _n_564 VSS OAI22
X_d_39 _n_635 _n_562 _n_501 _n_638 _n_4 VSS AND3_X1
X_d_40 _n_321 _n_299 _n_354 _n_4 VSS XNOR2
X_d_41 _n_259 _n_325 _n_323 _n_4 VSS XNOR2
X_d_42 _n_283 _n_323 _n_322 _n_4 VSS XNOR2
X_d_43 _n_256 _n_244 _n_234 _n_4 VSS XNOR2
X_d_44 _n_599 _n_592 _n_474 _n_4 VSS XNOR2
X_d_45 _n_452 _n_389 _n_499 _n_4 VSS XNOR2
X_d_46 _n_615 _n_614 _n_619 _n_4 VSS XNOR2
X_d_47 _n_489 _n_441 _n_473 _n_4 VSS XOR2
X_d_48 _n_208 _n_210 _n_165 _n_4 VSS XOR2
X_d_49 _n_307 _n_262 _n_299 _n_4 VSS XOR2
X_d_50 _n_255 _n_256 _n_233 _n_4 VSS XOR2
X_d_51 _n_508 _n_472 _n_4 _n_546 VSS NOR2
X_d_52 _n_452 _n_319 _n_4 _n_349 VSS NOR2
X_d_53 _n_317 _n_346 _n_4 _n_318 VSS NOR2
X_d_54 _n_514 _n_206 _n_4 _n_232 VSS NOR2
X_d_55 _n_358 _n_427 _n_4 _n_437 VSS NOR2
X_d_56 _n_474 _n_412 _n_4 _n_514 VSS NOR2
X_d_57 _n_319 _n_505 _n_4 _n_509 VSS NOR2
X_d_58 _n_300 _n_562 _n_4 _n_549 VSS NOR2
X_d_59 _n_333 _n_247 _n_4 _n_354 VSS NOR2
X_d_60 _n_347 _n_634 _n_4 _n_524 VSS NOR2
X_d_61 _n_604 _n_242 _n_4 _n_635 VSS NOR2
X_d_62 _n_50 _n_94 _n_4 _n_25 VSS NOR2
X_d_63 _n_427 _n_529 _n_4 _n_611 VSS NOR2
X_d_64 _n_51 _n_65 _n_4 _n_84 VSS NOR2
X_d_65 _n_345 _n_347 _n_4 _n_476 VSS NOR2
X_d_66 _n_44 _n_121 _n_4 _n_150 VSS NOR2
X_d_67 _n_96 _n_8 _n_4 _n_67 VSS NOR2
X_d_68 _n_473 _n_480 _n_4 _n_554 VSS NOR2
X_d_69 _n_522 _n_517 _n_4 _n_433 VSS NOR2
X_d_70 _n_565 _n_519 _n_4 _n_530 VSS NOR2
X_d_71 _n_288 _n_310 _n_4 _n_333 VSS NOR2
X_d_72 _n_14 _n_517 _n_4 _n_647 VSS NOR2
X_d_73 _n_403 _n_200 _n_4 _n_377 VSS NOR2
X_d_74 _n_267 _n_291 _n_4 _n_233 VSS NOR2
X_d_75 _n_339 _n_257 _n_4 _n_224 VSS NOR2
X_d_76 _n_324 _n_224 _n_283 _n_342 _n_316 _n_4 VSS AND4_X1
X_d_77 _n_228 _n_220 _n_4 _n_186 VSS NOR2
X_d_78 _n_554 _n_527 _n_4 _n_506 VSS NOR2
X_d_79 _n_418 _n_317 _n_4 _n_462 VSS NOR2
X_d_80 _n_562 _n_395 _n_4 _n_364 VSS NOR2
X_d_81 _n_564 _n_563 _n_4 _n_525 VSS NOR2
X_d_82 _n_33 _n_585 _n_4 _n_636 VSS NOR2
X_d_83 _n_585 _n_634 _n_4 _n_616 VSS NOR2
X_d_84 _n_24 _n_81 _n_4 _n_93 VSS NOR2
X_d_85 _n_395 _n_349 _n_4 _n_501 VSS NOR2
X_d_86 _n_445 _n_562 _n_4 _n_442 VSS NOR2
X_d_87 _n_209 _n_200 _n_4 _n_217 VSS NOR2
X_d_88 _n_565 _n_518 _n_4 _n_536 VSS NOR2
X_d_89 _n_393 _n_390 _n_4 _n_287 VSS NOR2
X_d_90 _n_147 _n_94 _n_4 _n_55 VSS NOR2
X_d_91 _n_360 _n_326 _n_4 _n_393 VSS NOR2
X_d_92 _n_418 _n_298 _n_4 _n_447 VSS NOR2
X_d_93 _n_545 _n_319 _n_4 _n_604 VSS NOR2
X_d_94 _n_611 _n_612 _n_4 _n_608 VSS NOR2
X_d_95 _n_255 _n_233 _n_4 _n_284 VSS NOR2
X_d_96 _n_541 _n_602 _n_4 _n_603 VSS NOR2
X_d_97 _n_452 _n_488 _n_480 _n_445 _n_4 VSS NOR3
X_d_98 _n_24 _n_80 _n_59 _n_28 _n_4 VSS NOR3
X_d_99 _n_564 _n_526 _n_600 _n_601 _n_4 VSS NOR3
X_d_100 _n_540 _n_550 _n_463 _n_531 _n_4 VSS NOR3
X_d_101 _n_228 _n_185 _n_220 _n_161 _n_4 VSS NOR3
X_d_102 _n_498 _n_507 _n_511 _n_185 _n_4 VSS NOR3
X_d_103 _n_202 _n_227 _n_180 _n_219 _n_4 VSS NOR3
X_d_104 _n_298 _n_346 _n_348 _n_264 _n_4 VSS NOR3
X_d_105 _n_315 _n_509 _n_506 _n_498 _n_4 VSS NOR3
X_d_106 _n_106 _n_127 _n_126 _n_116 _n_4 VSS NOR3
X_d_107 _n_545 _n_489 _n_473 _n_395 _n_4 VSS NOR3
X_d_108 _n_536 _n_530 _n_576 _n_472 _n_4 VSS NOR3
X_d_109 _n_106 _n_130 _n_75 _n_108 _n_4 VSS NOR3
X_d_110 _n_123 _n_143 _n_115 _n_100 _n_4 VSS NOR3
X_d_111 _n_452 _n_489 _n_488 _n_242 _n_4 VSS NOR3
X_d_112 _n_164 _n_642 _n_651 _n_661 _n_4 VSS NOR3
X_d_113 _n_545 _n_489 _n_488 _n_412 _n_4 VSS NOR3
X_d_114 _n_427 _n_418 _n_317 _n_257 _n_4 VSS NOR3
X_d_115 _n_106 _n_45 _n_235 _n_120 _n_4 VSS NOR3
X_d_116 _n_452 _n_489 _n_473 _n_337 _n_4 VSS NOR3
X_d_117 _n_312 _n_346 _n_194 _n_418 _n_309 _n_327 _n_418 _n_4 VSS MUXDFFRB
X_d_118 _n_312 _n_317 _n_260 _n_298 _n_268 _n_251 _n_298 _n_4 VSS MUXDFFRB
X_d_119 _n_312 _n_417 _n_144 _n_345 _n_357 _n_361 _n_345 _n_4 VSS MUXDFFRB
X_d_120 _n_326 _n_I2571 _n_308 _n_365 _n_309 _n_327 _n_308 _n_4 VSS MUXDFFRB
X_d_121 _n_169 _n_274 _n_62 _n_227 _n_268 _n_251 _n_227 _n_4 VSS MUXDFFRB
X_d_122 _n_312 _n_347 _n_236 _n_358 _n_357 _n_361 _n_358 _n_4 VSS MUXDFFRB
X_d_123 _n_169 _n_218 _n_118 _n_180 _n_173 _n_195 _n_180 _n_4 VSS MUXDFFRB
X_d_124 _n_377 _n_I2567 _n_330 _n_368 _n_309 _n_327 _n_330 _n_4 VSS MUXDFFRB
X_d_125 _n_601 _n_613 _n_599 _n_613 _n_642 _n_648 _n_599 _n_4 VSS MUXDFFRB
X_d_126 _n_64 _n_50 _n_236 _n_92 _n_268 _n_251 _n_250 _n_4 VSS MUXDFFRB
X_d_127 _n_472 _n_I2564 _n_385 _n_423 _n_415 _n_426 _n_385 _n_4 VSS MUXDFFRB
X_d_128 _n_472 _n_I2563 _n_410 _n_446 _n_415 _n_426 _n_410 _n_4 VSS MUXDFFRB
X_d_129 _n_326 _n_I2562 _n_328 _n_366 _n_309 _n_327 _n_328 _n_4 VSS MUXDFFRB
X_d_130 _n_472 _n_I2561 _n_477 _n_468 _n_481 _n_469 _n_477 _n_4 VSS MUXDFFRB
X_d_131 _n_106 _n_60 _n_170 _n_114 _n_124 _n_128 _n_141 _n_4 VSS MUXDFFRB
X_d_132 _n_500 _n_548 _n_369 _n_521 _n_481 _n_469 _n_369 _n_4 VSS MUXDFFRB
X_d_133 _n_169 _n_203 _n_71 _n_202 _n_173 _n_195 _n_202 _n_4 VSS MUXDFFRB
X_d_134 _n_64 _n_94 _n_144 _n_6 _n_124 _n_128 _n_145 _n_4 VSS MUXDFFRB
X_d_135 _n_154 _n_I2556 _n_160 _n_188 _n_173 _n_195 _n_188 _n_4 VSS MUXDFFRB
X_d_136 _n_64 _n_51 _n_194 _n_33 _n_173 _n_195 _n_182 _n_4 VSS MUXDFFRB
X_d_137 _n_326 _n_I2554 _n_382 _n_375 _n_357 _n_361 _n_382 _n_4 VSS MUXDFFRB
X_d_138 _n_425 _n_4 _n_288 VSS BUF_X2
X_d_139 _n_76 _n_4 _n_513 VSS BUF_X2
X_d_140 _n_573 _n_4 _n_585 VSS BUF_X2
X_d_141 _n_460 _n_4 _n_392 VSS BUF_X2
X_d_142 _n_250 _n_4 _n_147 VSS BUF_X2
X_d_143 _n_76 _n_4 _n_469 VSS BUF_X2
X_d_144 _n_76 _n_4 _n_195 VSS BUF_X2
X_d_145 _n_76 _n_4 _n_648 VSS BUF_X2
X_d_146 _n_145 _n_4 _n_77 VSS BUF_X2
X_d_147 _n_76 _n_4 _n_128 VSS BUF_X2
X_d_148 _n_383 _n_4 _n_280 VSS BUF_X2
X_d_149 _n_91 _n_4 _n_558 VSS BUF_X2
X_d_150 _n_417 _n_4 _n_304 VSS BUF_X2
X_d_151 _n_539 _n_4 _n_540 VSS BUF_X2
X_d_152 _n_538 _n_4 _n_562 VSS BUF_X2
X_d_153 _n_573 _n_4 _n_517 VSS BUF_X2
X_d_154 _n_425 _n_4 _n_408 VSS BUF_X2
X_d_155 _n_182 _n_4 _n_33 VSS BUF_X2
X_d_156 _n_581 _n_4 _n_440 VSS BUF_X2
X_d_157 _n_91 _n_4 _n_481 VSS BUF_X2
X_d_158 _n_182 _n_4 _n_8 VSS BUF_X2
X_d_159 _n_109 _n_4 _n_96 VSS BUF_X2
X_d_160 _n_94 _n_51 _n_149 _n_96 _n_50 _n_4 VSS OR4
X_d_161 _n_581 _n_4 _n_474 VSS BUF_X2
X_d_162 _n_141 _n_4 _n_114 VSS BUF_X2
X_d_163 _n_142 _n_4 _n_85 VSS BUF_X2
X_d_164 _n_539 _n_4 _n_399 VSS BUF_X2
X_d_165 _n_76 _n_4 _n_20 VSS BUF_X2
X_d_166 _n_141 _n_4 _n_71 VSS BUF_X2
X_d_167 _n_142 _n_4 _n_62 VSS BUF_X2
X_d_168 _n_91 _n_4 _n_415 VSS BUF_X2
X_d_169 _n_538 _n_4 _n_583 VSS BUF_X2
X_d_170 _n_91 _n_4 _n_642 VSS BUF_X2
X_d_171 _n_417 _n_4 _n_427 VSS BUF_X2
X_d_172 _n_376 _n_4 _n_510 VSS BUF_X2
X_d_173 _n_145 _n_4 _n_6 VSS BUF_X2
X_d_174 _n_91 _n_4 _n_124 VSS BUF_X2
X_d_175 _n_359 _n_4 _n_290 VSS BUF_X2
X_d_176 _n_109 _n_4 _n_14 VSS BUF_X2
X_d_177 _n_91 _n_4 _n_268 VSS BUF_X2
X_d_178 _n_91 _n_4 _n_309 VSS BUF_X2
X_d_179 _n_460 _n_4 _n_565 VSS BUF_X2
X_d_180 _n_107 _n_4 _n_125 VSS BUF_X2
X_d_181 _n_107 _n_4 _n_118 VSS BUF_X2
X_d_182 _n_91 _n_4 _n_357 VSS BUF_X2
X_d_183 _n_91 _n_4 _n_173 VSS BUF_X2
X_d_184 _n_383 _n_4 _n_343 VSS BUF_X2
X_d_185 _n_76 _n_4 _n_361 VSS BUF_X2
X_d_186 _n_76 _n_4 _n_327 VSS BUF_X2
X_d_187 _n_76 _n_4 _n_251 VSS BUF_X2
X_d_188 _n_376 _n_4 _n_230 VSS BUF_X2
X_d_189 _n_311 _n_4 _n_270 VSS BUF_X2
X_d_190 _n_311 _n_4 _n_310 VSS BUF_X2
X_d_191 _n_250 _n_4 _n_92 VSS BUF_X2
X_d_192 _n_76 _n_4 _n_426 VSS BUF_X2
X_d_193 _n_359 _n_4 _n_362 VSS BUF_X2
X_d_194 _n_I1024 _n_534 _n_469 _n_508 _n_4 _n_481 VSS DFFRB
X_d_195 _n_I1023 _n_553 _n_513 _n_541 _n_4 _n_558 VSS DFFRB
X_d_196 _n_I1022 _n_627 _n_513 _n_429 _n_4 _n_558 VSS DFFRB
X_d_197 _n_I1021 _n_606 _n_513 _n_580 _n_4 _n_558 VSS DFFRB
X_d_198 _n_I1020 _n_287 _n_251 _n_360 _n_4 _n_268 VSS DFFRB
X_d_199 _n_488 _n_441 _n_426 _n_473 _n_4 _n_415 VSS DFFRB
X_d_200 _n_460 _n_475 _n_426 _n_522 _n_4 _n_415 VSS DFFRB
X_d_201 _n_86 _n_32 _n_20 _n_107 _n_4 _n_90 VSS DFFRB
X_d_202 _n_91 _n_4 _n_90 VSS BUF_X2
X_d_203 _n_480 _n_480 _n_469 _n_489 _n_4 _n_481 VSS DFFRB
X_d_204 _n_99 _n_129 _n_128 _n_142 _n_4 _n_124 VSS DFFRB
X_d_205 _n_46 _n_131 _n_128 _n_19 _n_4 _n_124 VSS DFFRB
X_d_206 _n_545 _n_389 _n_361 _n_452 _n_4 _n_357 VSS DFFRB
X_d_207 _n_I1012 _n_607 _n_648 _n_543 _n_4 _n_642 VSS DFFRB
X_d_208 _n_I1011 _n_614 _n_648 _n_615 _n_4 _n_642 VSS DFFRB
X_d_209 _n_164 _n_4 _n_76 VSS INV_X1
X_d_210 _n_98 _n_4 _n_123 VSS INV_X1
X_d_211 _n_408 _n_4 _n_386 VSS INV_X1
X_d_212 _n_50 _n_4 _n_83 VSS INV_X1
X_d_213 _n_218 _n_4 _n_204 VSS INV_X1
X_d_214 _n_585 _n_4 _n_581 VSS INV_X1
X_d_215 _n_407 _n_4 _n_348 VSS INV_X1
X_d_216 _n_274 _n_4 _n_276 VSS INV_X1
X_d_217 _n_429 _n_4 _n_621 VSS INV_X1
X_d_218 _n_203 _n_4 _n_175 VSS INV_X1
X_d_219 _n_467 _n_4 _n_449 VSS INV_X1
X_d_220 _n_335 _n_4 _n_314 VSS INV_X1
X_d_221 _n_362 _n_4 _n_340 VSS INV_X1
X_d_222 _n_260 _n_4 _n_277 VSS INV_X1
X_d_223 _n_280 _n_4 _n_332 VSS INV_X1
X_d_224 _n_118 _n_4 _n_119 VSS INV_X1
X_d_225 _n_452 _n_4 _n_339 VSS INV_X1
X_d_226 _n_194 _n_4 _n_172 VSS INV_X1
X_d_227 _n_325 _n_4 _n_222 VSS INV_X1
X_d_228 _n_147 _n_4 _n_174 VSS INV_X1
X_d_229 _n_19 _n_4 _n_101 VSS INV_X1
X_d_230 _n_71 _n_4 _n_400 VSS INV_X1
X_d_231 _n_43 _n_4 _n_15 VSS INV_X1
X_d_232 _n_62 _n_4 _n_213 VSS INV_X1
X_d_233 _n_144 _n_4 _n_221 VSS INV_X1
X_d_234 _n_615 _n_4 _n_610 VSS INV_X1
X_d_235 _n_599 _n_4 _n_640 VSS INV_X1
X_d_236 _n_236 _n_4 _n_197 VSS INV_X1
X_d_237 _n_522 _n_4 _n_556 VSS INV_X1
X_d_238 _n_432 _n_4 _n_491 VSS INV_X1
X_d_239 _n_638 _n_4 _n_618 VSS INV_X1
X_d_240 _n_77 _n_4 _n_35 VSS INV_X1
X_d_241 _n_597 _n_4 _n_602 VSS INV_X1
X_d_242 _n_370 _n_4 _n_371 VSS INV_X1
X_d_243 _n_221 _n_209 _n_113 _n_190 _n_4 VSS AOI21
X_d_244 _n_583 _n_582 _n_641 _n_651 _n_4 VSS AOI21
X_d_245 _n_585 _n_597 _n_244 _n_644 _n_4 VSS AOI21
X_d_246 _n_178 _n_273 _n_239 _n_292 _n_4 VSS AOI21
X_d_247 _n_136 _n_139 _n_113 _n_151 _n_4 VSS AOI21
X_d_248 _n_364 _n_413 _n_210 _n_390 _n_4 VSS AOI21
X_d_249 _n_259 _n_324 _n_323 _n_307 _n_4 VSS AOI21
X_d_250 _n_226 _n_273 _n_240 _n_225 _n_4 VSS AOI21
X_d_251 _n_358 _n_345 _n_347 _n_406 _n_4 VSS AOI21
X_d_252 _n_178 _n_273 _n_272 _n_296 _n_4 VSS AOI21
X_d_253 _n_358 _n_304 _n_347 _n_407 _n_4 VSS AOI21
X_d_254 _n_197 _n_209 _n_113 _n_265 _n_4 VSS AOI21
X_d_255 _n_123 _n_512 _n_453 _n_511 _n_4 VSS AOI21
X_d_256 _n_55 _n_133 _n_67 _n_54 _n_4 VSS AOI21
X_d_257 _n_522 _n_548 _n_535 _n_372 _n_4 VSS AOI21
X_d_258 _n_400 _n_399 _n_367 _n_435 _n_4 VSS AOI21
X_d_259 _n_462 _n_517 _n_476 _n_526 _n_4 VSS AOI21
X_d_260 _n_319 _n_315 _n_314 _n_305 _n_4 VSS AOI21
X_d_261 _n_319 _n_315 _n_371 _n_336 _n_4 VSS AOI21
X_d_262 _n_386 _n_339 _n_257 _n_384 _n_4 VSS AOI21
X_d_263 _n_520 _n_546 _n_555 _n_534 _n_4 VSS AOI21
X_d_264 _n_585 _n_597 _n_325 _n_598 _n_4 VSS AOI21
X_d_265 _n_319 _n_315 _n_449 _n_450 _n_4 VSS AOI21
X_d_266 _n_524 _n_557 _n_337 _n_551 _n_4 VSS AOI21
X_d_267 _n_58 _n_31 _n_88 _n_75 _n_4 VSS AOI21
X_d_268 _n_31 _n_4 _n_42 VSS INV_X1
X_d_269 _n_119 _n_120 _n_106 _n_32 _n_4 VSS AOI21
X_d_270 _n_332 _n_339 _n_257 _n_282 _n_4 VSS AOI21
X_d_271 _n_540 _n_470 _n_566 _n_577 _n_4 VSS AOI21
X_d_272 _n_277 _n_209 _n_113 _n_261 _n_4 VSS AOI21
X_d_273 _n_340 _n_339 _n_257 _n_355 _n_4 VSS AOI21
X_d_274 _n_135 _n_79 _n_111 _n_134 _n_4 VSS AOI21
X_d_275 _n_58 _n_31 _n_89 _n_45 _n_4 VSS AOI21
X_d_276 _n_123 _n_399 _n_367 _n_492 _n_4 VSS AOI21
X_d_277 _n_28 _n_12 _n_37 _n_89 _n_4 VSS AOI21
X_d_278 _n_18 _n_117 _n_20 _n_98 _n_4 _n_90 VSS DFFRB
X_d_279 _n_629 _n_603 _n_644 _n_553 _n_4 VSS AOI21
X_d_280 _n_367 _n_200 _n_448 _n_470 _n_4 VSS AOI21
X_d_281 _n_172 _n_209 _n_113 _n_191 _n_4 VSS AOI21
X_d_282 _n_177 _n_248 _n_294 _n_267 _n_4 VSS AOI21
X_d_283 _n_217 _n_242 _n_157 _n_201 _n_4 VSS AOI21
X_d_284 _n_177 _n_215 _n_237 _n_285 _n_4 VSS AOI21
X_d_285 _n_213 _n_399 _n_367 _n_396 _n_4 VSS AOI21
X_d_286 _n_510 _n_507 _n_232 _n_497 _n_4 VSS AOI21
X_d_287 _n_71 _n_62 _n_99 _n_115 _n_4 VSS AOI21
X_d_288 _n_585 _n_616 _n_528 _n_571 _n_4 VSS AOI21
X_d_289 _n_137 _n_138 _n_149 _n_102 _n_4 VSS AOI21
X_d_290 _n_119 _n_399 _n_367 _n_414 _n_4 VSS AOI21
X_d_291 _n_208 _n_165 _n_4 _n_155 VSS AND2_X1
X_d_292 _n_149 _n_54 _n_4 _n_199 VSS AND2_X1
X_d_293 _n_522 _n_474 _n_4 _n_432 VSS AND2_X1
X_d_294 _n_337 _n_479 _n_4 _n_507 VSS AND2_X1
X_d_295 _n_177 _n_270 _n_4 _n_168 VSS AND2_X1
X_d_296 _n_42 _n_87 _n_4 _n_126 VSS AND2_X1
X_d_297 _n_392 _n_412 _n_4 _n_136 VSS AND2_X1
X_d_298 _n_51 _n_217 _n_4 _n_176 VSS AND2_X1
X_d_299 _n_406 _n_318 _n_4 _n_229 VSS AND2_X1
X_d_300 _n_565 _n_550 _n_4 _n_566 VSS AND2_X1
X_d_301 _n_136 _n_112 _n_4 _n_139 VSS AND2_X1
X_d_302 _n_589 _n_587 _n_650 _n_657 _n_4 VSS NAND3
X_d_303 _n_587 _n_575 _n_656 _n_582 _n_4 VSS NAND3
X_d_304 _n_21 _n_47 _n_48 _n_12 _n_4 VSS NAND3
X_d_305 _n_147 _n_236 _n_138 _n_295 _n_4 VSS NAND3
X_d_306 _n_260 _n_237 _n_238 _n_239 _n_4 VSS MUX2
X_d_307 _n_391 _n_401 _n_402 _n_366 _n_4 VSS NAND3
X_d_308 _n_501 _n_649 _n_588 _n_659 _n_4 VSS NAND3
X_d_309 _n_326 _n_455 _n_456 _n_413 _n_4 VSS NAND3
X_d_310 _n_98 _n_176 _n_206 _n_281 _n_4 VSS NAND3
X_d_311 _n_125 _n_176 _n_206 _n_207 _n_4 VSS NAND3
X_d_312 _n_185 _n_165 _n_186 _n_4 VSS XNOR2
X_d_313 _n_114 _n_176 _n_206 _n_184 _n_4 VSS NAND3
X_d_314 _n_85 _n_176 _n_206 _n_380 _n_4 VSS NAND3
X_d_315 _n_258 _n_279 _n_243 _n_283 _n_4 VSS NAND3
X_d_316 _n_174 _n_197 _n_138 _n_198 _n_4 VSS NAND3
X_d_317 _n_403 _n_485 _n_482 _n_503 _n_4 VSS NAND3
X_d_318 _n_381 _n_438 _n_373 _n_321 _n_4 VSS NAND3
X_d_319 _n_224 _n_196 _n_214 _n_187 _n_4 VSS NAND3
X_d_320 _n_28 _n_104 _n_135 _n_97 _n_4 VSS NAND3
X_d_321 _n_138 _n_137 _n_149 _n_112 _n_4 VSS NAND3
X_d_322 _n_569 _n_567 _n_551 _n_576 _n_4 VSS NAND3
X_d_323 _n_246 _n_266 _n_289 _n_235 _n_4 VSS NAND3
X_d_324 _n_46 _n_67 _n_25 _n_53 _n_4 VSS NAND3
X_d_325 _n_363 _n_374 _n_388 _n_375 _n_4 VSS NAND3
X_d_326 _n_224 _n_342 _n_316 _n_322 _n_4 VSS NAND3
X_d_327 _n_135 _n_136 _n_121 _n_169 _n_4 VSS NAND3
X_d_328 _n_398 _n_397 _n_411 _n_365 _n_4 VSS NAND3
X_d_329 _n_358 _n_345 _n_317 _n_464 _n_4 VSS NAND3
X_d_330 _n_50 _n_392 _n_535 _n_612 _n_4 VSS NAND3
X_d_331 _n_35 _n_83 _n_67 _n_69 _n_4 VSS NAND3
X_d_332 _n_281 _n_497 _n_478 _n_532 _n_4 VSS NAND3
X_d_333 _n_502 _n_486 _n_494 _n_475 _n_4 VSS NAND3
X_d_334 _n_399 _n_547 _n_574 _n_521 _n_4 VSS NAND3
X_d_335 _n_149 _n_135 _n_93 _n_103 _n_4 VSS NAND3
X_d_336 _n_139 _n_103 _n_153 _n_79 _n_4 VSS NAND3
X_d_337 _n_70 _n_95 _n_68 _n_157 _n_4 VSS NAND3
X_d_338 _n_369 _n_300 _n_514 _n_575 _n_4 VSS NAND3
X_d_339 _n_174 _n_35 _n_84 _n_104 _n_4 VSS NAND3
X_d_340 _n_198 _n_295 _n_226 _n_294 _n_4 VSS NAND3
X_d_341 _n_306 _n_338 _n_356 _n_255 _n_4 VSS NAND3
X_d_342 _n_4 VSS FILL2
X_d_343 _n_4 VSS FILL2
X_d_344 _n_4 VSS FILL2
X_d_345 _n_4 VSS FILL2
X_d_346 _n_4 VSS FILL2
X_d_347 _n_4 VSS FILL2
X_d_348 _n_4 VSS FILL2
X_d_349 _n_4 VSS FILL2
X_d_350 _n_4 VSS FILL2
X_d_351 _n_4 VSS FILL2
X_d_352 _n_4 VSS FILL2
X_d_353 _n_4 VSS FILL2
X_d_354 _n_4 VSS FILL2
X_d_355 _n_4 VSS FILL2
X_d_356 _n_4 VSS FILL2
X_d_357 _n_4 VSS FILL2
X_d_358 _n_4 VSS FILL2
X_d_359 _n_4 VSS FILL2
X_d_360 _n_4 VSS FILL2
X_d_361 _n_4 VSS FILL2
X_d_362 _n_4 VSS FILL2
X_d_363 _n_4 VSS FILL2
X_d_364 _n_4 VSS FILL2
X_d_365 _n_4 VSS FILL2
X_d_366 _n_4 VSS FILL2
X_d_367 _n_4 VSS FILL2
X_d_368 _n_4 VSS FILL2
X_d_369 _n_4 VSS FILL2
X_d_370 _n_4 VSS FILL2
X_d_371 _n_4 VSS FILL2
X_d_372 _n_4 VSS FILL2
X_d_373 _n_4 VSS FILL2
X_d_374 _n_4 VSS FILL2
X_d_375 _n_4 VSS FILL2
X_d_376 _n_474 _n_612 _n_591 _n_566 _n_589 _n_4 VSS NAND4
X_d_377 _n_444 _n_416 _n_424 _n_434 _n_423 _n_4 VSS NAND4
X_d_378 _n_436 _n_457 _n_459 _n_458 _n_446 _n_4 VSS NAND4
X_d_379 _n_147 _n_392 _n_447 _n_407 _n_591 _n_4 VSS NAND4
X_d_380 _n_290 _n_230 _n_288 _n_343 _n_368 _n_4 VSS NAND4
X_d_381 _n_438 _n_431 _n_380 _n_419 _n_471 _n_4 VSS NAND4
X_d_382 _n_95 _n_52 _n_53 _n_49 _n_111 _n_4 VSS NAND4
X_d_383 _n_466 _n_422 _n_421 _n_443 _n_468 _n_4 VSS NAND4
X_d_384 _n_50 _n_447 _n_407 _n_433 _n_502 _n_4 VSS NAND4
X_d_385 _n_54 _n_95 _n_68 _n_69 _n_81 _n_4 VSS NAND4
X_d_386 _n_104 _n_82 _n_95 _n_150 _n_113 _n_4 VSS NAND4
X_d_387 _n_92 _n_412 _n_634 _n_591 _n_649 _n_4 VSS NAND4
X_d_388 _n_338 _n_352 _n_350 _n_207 _n_152 _n_4 VSS NAND4
X_d_389 _n_147 _n_392 _n_447 _n_437 _n_206 _n_4 VSS NAND4
X_d_390 _n_171 _n_61 _n_211 _n_166 _n_170 _n_4 VSS NAND4
X_d_391 _n_634 _n_612 _n_591 _n_577 _n_641 _n_4 VSS NAND4
X_d_392 _n_279 _n_253 _n_184 _n_254 _n_334 _n_4 VSS NAND4
X_d_393 _n_98 _n_41 _n_63 _n_118 _n_4 _n_49 VSS AOI22
X_d_394 _n_64 _n_65 _n_260 _n_14 _n_90 _n_20 _n_109 _n_4 VSS MUXDFFRB
X_d_395 _n_213 _n_192 _n_106 _n_116 _n_4 _n_129 VSS AOI22
X_d_396 _n_349 _n_527 _n_505 _n_242 _n_4 _n_478 VSS AOI22
X_d_397 _n_46 _n_59 _n_44 _n_86 _n_4 _n_47 VSS AOI22
X_d_398 _n_410 _n_595 _n_571 _n_328 _n_4 _n_622 VSS AOI22
X_d_399 _n_50 _n_549 _n_433 _n_369 _n_4 _n_574 VSS AOI22
X_d_400 _n_580 _n_595 _n_604 _n_360 _n_4 _n_631 VSS AOI22
X_d_401 _n_77 _n_11 _n_19 _n_14 _n_4 _n_7 VSS AOI22
X_d_402 _n_8 _n_78 _n_9 _n_4 VSS XOR2
X_d_403 _n_194 _n_432 _n_445 _n_360 _n_4 _n_516 VSS AOI22
X_d_404 _n_524 _n_501 _n_349 _n_514 _n_4 _n_484 VSS AOI22
X_d_405 _n_410 _n_395 _n_474 _n_144 _n_4 _n_402 VSS AOI22
X_d_406 _n_19 _n_59 _n_44 _n_60 _n_4 _n_5 VSS AOI22
X_d_407 _n_58 _n_29 _n_39 _n_87 _n_4 VSS NAND3
X_d_408 _n_118 _n_41 _n_63 _n_62 _n_4 _n_73 VSS AOI22
X_d_409 _n_144 _n_432 _n_445 _n_328 _n_4 _n_458 VSS AOI22
X_d_410 _n_101 _n_146 _n_79 _n_134 _n_4 _n_131 VSS AOI22
X_d_411 _n_370 _n_232 _n_242 _n_362 _n_4 _n_350 VSS AOI22
X_d_412 _n_71 _n_41 _n_63 _n_98 _n_4 _n_29 VSS AOI22
X_d_413 _n_30 _n_74 _n_4 _n_88 VSS AND2_X1
X_d_414 _n_62 _n_44 _n_63 _n_30 _n_4 VSS AOI21
X_d_415 _n_335 _n_232 _n_242 _n_280 _n_4 _n_254 VSS AOI22
X_d_416 _n_123 _n_156 _n_106 _n_108 _n_4 _n_117 VSS AOI22
X_d_417 _n_467 _n_232 _n_242 _n_408 _n_4 _n_419 VSS AOI22
X_d_418 _n_477 _n_412 _n_440 _n_408 _n_4 _n_411 VSS AOI22
X_d_419 _n_290 _n_432 _n_433 _n_382 _n_4 _n_434 VSS AOI22
X_d_420 _n_290 _n_229 _n_264 _n_92 _n_4 _n_289 VSS AOI22
X_d_421 _n_280 _n_229 _n_264 _n_6 _n_4 _n_211 VSS AOI22
X_d_422 _n_288 _n_445 _n_433 _n_260 _n_4 _n_443 VSS AOI22
X_d_423 _n_508 _n_412 _n_440 _n_510 _n_4 _n_456 VSS AOI22
X_d_424 _n_230 _n_229 _n_264 _n_33 _n_4 _n_223 VSS AOI22
X_d_425 _n_288 _n_229 _n_264 _n_14 _n_4 _n_263 VSS AOI22
X_d_426 _n_19 _n_59 _n_41 _n_18 _n_4 _n_74 VSS AOI22
X_d_427 _n_385 _n_395 _n_440 _n_236 _n_4 _n_374 VSS AOI22
X_d_428 _n_477 _n_595 _n_571 _n_308 _n_4 _n_572 VSS AOI22
X_d_429 _n_385 _n_595 _n_571 _n_382 _n_4 _n_560 VSS AOI22
X_d_430 _n_392 _n_395 _n_64 _n_4 VSS NAND2
X_d_431 _n_517 _n_399 _n_538 _n_4 VSS NAND2
X_d_432 _n_54 _n_135 _n_110 _n_4 VSS NAND2
X_d_433 _n_634 _n_612 _n_590 _n_4 VSS NAND2
X_d_434 _n_149 _n_54 _n_80 _n_4 VSS NAND2
X_d_435 _n_543 _n_597 _n_637 _n_4 VSS NAND2
X_d_436 _n_321 _n_354 _n_286 _n_4 VSS NAND2
X_d_437 _n_392 _n_412 _n_200 _n_4 VSS NAND2
X_d_438 _n_508 _n_571 _n_596 _n_4 VSS NAND2
X_d_439 _n_55 _n_67 _n_70 _n_4 VSS NAND2
X_d_440 _n_633 _n_572 _n_653 _n_4 VSS NAND2
X_d_441 _n_113 _n_265 _n_266 _n_4 VSS NAND2
X_d_442 _n_276 _n_163 _n_275 _n_4 VSS NAND2
X_d_443 _n_596 _n_631 _n_652 _n_4 VSS NAND2
X_d_444 _n_447 _n_476 _n_485 _n_4 VSS NAND2
X_d_445 _n_580 _n_597 _n_605 _n_4 VSS NAND2
X_d_446 _n_429 _n_604 _n_594 _n_4 VSS NAND2
X_d_447 _n_541 _n_604 _n_630 _n_4 VSS NAND2
X_d_448 _n_594 _n_622 _n_658 _n_4 VSS NAND2
X_d_449 _n_67 _n_25 _n_68 _n_4 VSS NAND2
X_d_450 _n_209 _n_133 _n_226 _n_4 VSS NAND2
X_d_451 _n_630 _n_560 _n_662 _n_4 VSS NAND2
X_d_452 _n_367 _n_414 _n_416 _n_4 VSS NAND2
X_d_453 _n_369 _n_242 _n_656 _n_4 VSS NAND2
X_d_454 _n_300 _n_159 _n_154 _n_4 VSS NAND2
X_d_455 _n_543 _n_604 _n_633 _n_4 VSS NAND2
X_d_456 _n_113 _n_190 _n_166 _n_4 VSS NAND2
X_d_457 _n_362 _n_412 _n_388 _n_4 VSS NAND2
X_d_458 _n_19 _n_93 _n_52 _n_4 VSS NAND2
X_d_459 _n_474 _n_461 _n_518 _n_4 VSS NAND2
X_d_460 _n_42 _n_40 _n_61 _n_4 VSS NAND2
X_d_461 _n_601 _n_592 _n_619 _n_4 VSS NAND2
X_d_462 _n_209 _n_168 _n_216 _n_4 VSS NAND2
X_d_463 _n_216 _n_264 _n_229 _n_31 _n_4 VSS OR3
X_d_464 _n_418 _n_465 _n_448 _n_4 VSS NAND2
X_d_465 _n_343 _n_433 _n_459 _n_4 VSS NAND2
X_d_466 _n_611 _n_583 _n_650 _n_4 VSS NAND2
X_d_467 _n_147 _n_138 _n_238 _n_4 VSS NAND2
X_d_468 _n_367 _n_492 _n_490 _n_4 VSS NAND2
X_d_469 _n_204 _n_163 _n_241 _n_4 VSS NAND2
X_d_470 _n_14 _n_562 _n_639 _n_4 VSS NAND2
X_d_471 _n_230 _n_433 _n_483 _n_4 VSS NAND2
X_d_472 _n_260 _n_395 _n_397 _n_4 VSS NAND2
X_d_473 _n_6 _n_562 _n_609 _n_4 VSS NAND2
X_d_474 _n_522 _n_447 _n_529 _n_4 VSS NAND2
X_d_475 _n_298 _n_464 _n_465 _n_4 VSS NAND2
X_d_476 _n_439 _n_349 _n_431 _n_4 VSS NAND2
X_d_477 _n_175 _n_163 _n_205 _n_4 VSS NAND2
X_d_478 _n_71 _n_41 _n_48 _n_4 VSS NAND2
X_d_479 _n_462 _n_406 _n_482 _n_4 VSS NAND2
X_d_480 _n_343 _n_412 _n_401 _n_4 VSS NAND2
X_d_481 _n_522 _n_535 _n_300 _n_4 VSS NAND2
X_d_482 _n_337 _n_451 _n_438 _n_4 VSS NAND2
X_d_483 _n_255 _n_233 _n_245 _n_4 VSS NAND2
X_d_484 _n_364 _n_244 _n_363 _n_4 VSS NAND2
X_d_485 _n_163 _n_219 _n_158 _n_4 VSS NAND2
X_d_486 _n_8 _n_583 _n_586 _n_4 VSS NAND2
X_d_487 _n_167 _n_223 _n_130 _n_4 VSS NAND2
X_d_488 _n_222 _n_364 _n_391 _n_4 VSS NAND2
X_d_489 _n_19 _n_231 _n_196 _n_4 VSS NAND2
X_d_490 _n_337 _n_353 _n_279 _n_4 VSS NAND2
X_d_491 _n_367 _n_435 _n_457 _n_4 VSS NAND2
X_d_492 _n_113 _n_191 _n_167 _n_4 VSS NAND2
X_d_493 _n_308 _n_432 _n_421 _n_4 VSS NAND2
X_d_494 _n_194 _n_395 _n_455 _n_4 VSS NAND2
X_d_495 _n_564 _n_584 _n_569 _n_4 VSS NAND2
X_d_496 _n_351 _n_349 _n_352 _n_4 VSS NAND2
X_d_497 _n_337 _n_394 _n_338 _n_4 VSS NAND2
X_d_498 _n_367 _n_396 _n_422 _n_4 VSS NAND2
X_d_499 _n_452 _n_453 _n_228 _n_4 VSS NAND2
X_d_500 _n_556 _n_445 _n_567 _n_4 VSS NAND2
X_d_501 _n_23 _n_34 _n_24 _n_4 VSS NAND2
X_d_502 _n_565 _n_445 _n_312 _n_4 VSS NAND2
X_d_503 _n_236 _n_445 _n_424 _n_4 VSS NAND2
X_d_504 _n_113 _n_261 _n_278 _n_4 VSS NAND2
X_d_505 _n_320 _n_349 _n_253 _n_4 VSS NAND2
X_d_506 _n_489 _n_473 _n_499 _n_4 VSS NAND2
X_d_507 _n_101 _n_137 _n_148 _n_4 VSS NAND2
X_d_508 _n_462 _n_407 _n_367 _n_4 VSS NAND2
X_d_509 _n_46 _n_270 _n_215 _n_4 VSS NAND2
X_d_510 _n_262 _n_364 _n_398 _n_4 VSS NAND2
X_d_511 _n_367 _n_487 _n_550 _n_4 VSS NAND2
X_d_512 _n_174 _n_138 _n_237 _n_4 VSS NAND2
X_d_513 _n_433 _n_503 _n_486 _n_4 VSS NAND2
X_d_514 _n_522 _n_517 _n_494 _n_4 VSS NAND2
X_d_515 _n_92 _n_440 _n_629 _n_4 VSS NAND2
X_d_516 _n_278 _n_263 _n_127 _n_4 VSS NAND2
X_d_517 _n_515 _n_300 _n_537 _n_4 _n_597 VSS OAI21
X_d_518 _n_561 _n_545 _n_319 _n_4 _n_528 VSS OAI21
X_d_519 _n_602 _n_440 _n_210 _n_4 _n_646 VSS OAI21
X_d_520 _n_605 _n_636 _n_646 _n_4 _n_606 VSS OAI21
X_d_521 _n_598 _n_6 _n_585 _n_4 _n_643 VSS OAI21
X_d_522 _n_602 _n_440 _n_262 _n_4 _n_617 VSS OAI21
X_d_523 _n_300 _n_445 _n_528 _n_4 _n_587 VSS OAI21
X_d_524 _n_637 _n_647 _n_617 _n_4 _n_607 VSS OAI21
X_d_525 _n_583 _n_540 _n_463 _n_4 _n_600 VSS OAI21
X_d_526 _n_561 _n_585 _n_634 _n_4 _n_595 VSS OAI21
X_d_527 _n_643 _n_621 _n_602 _n_4 _n_627 VSS OAI21
X_d_528 _n_445 _n_369 _n_522 _n_4 _n_547 VSS OAI21
X_d_529 _n_450 _n_319 _n_439 _n_4 _n_381 VSS OAI21
X_d_530 _n_262 _n_442 _n_396 _n_4 _n_466 VSS OAI21
X_d_531 _n_569 _n_568 _n_242 _n_4 _n_578 VSS OAI21
X_d_532 _n_244 _n_442 _n_414 _n_4 _n_444 VSS OAI21
X_d_533 _n_452 _n_510 _n_453 _n_4 _n_512 VSS OAI21
X_d_534 _n_339 _n_489 _n_473 _n_4 _n_315 VSS OAI21
X_d_535 _n_262 _n_162 _n_261 _n_4 _n_192 VSS OAI21
X_d_536 _n_224 _n_292 _n_293 _n_4 _n_247 VSS OAI21
X_d_537 _n_244 _n_162 _n_265 _n_4 _n_246 VSS OAI21
X_d_538 _n_169 _n_200 _n_206 _n_4 _n_179 VSS OAI21
X_d_539 _n_310 _n_290 _n_177 _n_4 _n_248 VSS OAI21
X_d_540 _n_336 _n_319 _n_351 _n_4 _n_306 VSS OAI21
X_d_541 _n_384 _n_85 _n_257 _n_4 _n_373 VSS OAI21
X_d_542 _n_245 _n_284 _n_234 _n_4 _n_259 VSS OAI21
X_d_543 _n_305 _n_319 _n_320 _n_4 _n_258 VSS OAI21
X_d_544 _n_282 _n_114 _n_257 _n_4 _n_243 VSS OAI21
X_d_545 _n_286 _n_307 _n_299 _n_4 _n_208 VSS OAI21
X_d_546 _n_355 _n_125 _n_257 _n_4 _n_356 VSS OAI21
X_d_547 _n_222 _n_190 _n_162 _n_4 _n_171 VSS OAI21
X_d_548 _n_210 _n_162 _n_191 _n_4 _n_156 VSS OAI21
X_d_549 _n_535 _n_565 _n_540 _n_4 _n_584 VSS OAI21
X_d_550 _n_270 _n_230 _n_177 _n_4 _n_249 VSS OAI21
X_d_551 _n_224 _n_290 _n_310 _n_4 _n_291 VSS OAI21
X_d_552 _n_270 _n_273 _n_238 _n_4 _n_231 VSS OAI21
X_d_553 _n_310 _n_288 _n_177 _n_4 _n_293 VSS OAI21
X_d_554 _n_310 _n_343 _n_177 _n_4 _n_329 VSS OAI21
X_d_555 _n_102 _n_100 _n_148 _n_4 _n_178 VSS OAI21
X_d_556 _n_19 _n_13 _n_63 _n_4 _n_21 VSS OAI21
X_d_557 _n_168 _n_199 _n_31 _n_4 _n_162 VSS OAI21
X_d_558 _n_84 _n_55 _n_25 _n_4 _n_82 VSS OAI21
X_d_559 _n_97 _n_135 _n_31 _n_4 _n_140 VSS OAI21
X_d_560 _n_7 _n_174 _n_16 _n_4 _n_9 VSS OAI21
X_d_561 _n_210 _n_442 _n_492 _n_4 _n_520 VSS OAI21
X_d_562 _n_635 _n_608 _n_609 _n_4 _n_645 VSS OAI21
X_d_563 _n_222 _n_442 _n_435 _n_4 _n_436 VSS OAI21
X_d_564 _n_474 _n_92 _n_590 _n_4 _n_588 VSS OAI21
X_d_565 _n_4 VSS FILL3
X_d_566 _n_4 VSS FILL3
X_d_567 _n_4 VSS FILL3
X_d_568 _n_4 VSS FILL3
X_d_569 _n_4 VSS FILL3
X_d_570 _n_4 VSS FILL3
X_d_571 _n_4 VSS FILL3
X_d_572 _n_4 VSS FILL3
X_d_573 _n_4 VSS FILL3
X_d_574 _n_4 VSS FILL3
X_d_575 _n_4 VSS FILL3
X_d_576 _n_4 VSS FILL3
X_d_577 _n_4 VSS FILL3
X_d_578 _n_4 VSS FILL3
X_d_579 _n_4 VSS FILL3
X_d_580 _n_4 VSS FILL3
X_d_581 _n_4 VSS FILL3
X_d_582 _n_4 VSS FILL3
X_d_583 _n_4 VSS FILL3
X_d_584 _n_4 VSS FILL3
X_d_585 _n_4 VSS FILL3
X_d_586 _n_4 VSS FILL3
X_d_587 _n_4 VSS FILL3
X_d_588 _n_4 VSS FILL3
X_d_589 _n_4 VSS FILL3
X_d_590 _n_4 VSS FILL3
X_d_591 _n_4 VSS FILL3
X_d_592 _n_4 VSS FILL3
X_d_593 _n_4 VSS FILL3
X_d_594 _n_4 VSS FILL3
X_d_595 _n_4 VSS FILL3
X_d_596 _n_4 VSS FILL3
X_d_597 _n_4 VSS FILL3
X_d_598 _n_4 VSS FILL3
X_d_599 _n_4 VSS FILL3
X_d_600 _n_4 VSS FILL3
X_d_601 _n_4 VSS FILL3
X_d_602 _n_4 VSS FILL3
X_d_603 _n_4 VSS FILL3
X_d_604 _n_4 VSS FILL3
X_d_605 _n_4 VSS FILL3
X_d_606 _n_4 VSS FILL3
X_d_607 _n_4 VSS FILL3
X_d_608 _n_4 VSS FILL3
X_d_609 _n_4 VSS FILL3
X_d_610 _n_4 VSS FILL3
X_d_611 _n_4 VSS FILL3
X_d_612 _n_4 VSS FILL3
X_d_613 _n_4 VSS FILL3
X_d_614 _n_4 VSS FILL3
X_d_615 _n_4 VSS FILL3
X_d_616 _n_4 VSS FILL3
X_d_617 _n_4 VSS FILL3
X_d_618 _n_4 VSS FILL3
X_d_619 _n_4 VSS FILL3
X_d_620 _n_4 VSS FILL3
X_d_621 _n_4 VSS FILL3
X_d_622 _n_4 VSS FILL3
X_d_623 _n_4 VSS FILL3
X_d_624 _n_4 VSS FILL3
X_d_625 _n_4 VSS FILL3
X_d_626 _n_4 VSS FILL3
X_d_627 _n_110 _n_161 _n_155 _n_93 _n_4 _n_146 VSS OAI22
X_d_628 _n_4 VSS FILL3
X_d_629 _n_4 VSS FILL3
X_d_630 _n_4 VSS FILL3
X_d_631 _n_4 VSS FILL3
X_d_632 _n_4 VSS FILL3
X_d_633 _n_4 VSS FILL3
X_d_634 _n_4 VSS FILL3
X_d_635 _n_4 VSS FILL3
X_d_636 _n_4 VSS FILL3
X_d_637 _n_4 VSS FILL3
X_d_638 _n_4 VSS FILL3
X_d_639 _n_4 VSS FILL3
X_d_640 _n_4 VSS FILL3
X_d_641 _n_4 VSS FILL3
X_d_642 _n_4 VSS FILL3
X_d_643 _n_4 VSS FILL3
X_d_644 _n_4 VSS FILL3
X_d_645 _n_4 VSS FILL3
X_d_646 _n_4 VSS FILL3
X_d_647 _n_4 VSS FILL3
X_d_648 _n_4 VSS FILL3
X_d_649 _n_4 VSS FILL3
X_d_650 _n_4 VSS FILL3
X_d_651 _n_4 VSS FILL3
X_d_652 _n_4 VSS FILL3
X_d_653 _n_4 VSS FILL3
X_d_654 _n_4 VSS FILL3
X_d_655 _n_4 VSS FILL3
X_d_656 _n_4 VSS FILL3
X_d_657 _n_4 VSS FILL3
X_d_658 _n_4 VSS FILL3
X_d_659 _n_4 VSS FILL3
X_d_660 _n_4 VSS FILL3
X_d_661 _n_4 VSS FILL3
X_d_662 _n_4 VSS FILL3
X_d_663 _n_4 VSS FILL3
X_d_664 _n_4 VSS FILL3
X_d_665 _n_4 VSS FILL3
X_d_666 _n_4 VSS FILL3
X_d_667 _n_4 VSS FILL3
X_d_668 _n_4 VSS FILL3
X_d_669 _n_4 VSS FILL3
X_d_670 _n_4 VSS FILL3
X_d_671 _n_4 VSS FILL3
X_d_672 _n_4 VSS FILL3
X_d_673 _n_4 VSS FILL3
X_d_674 _n_4 VSS FILL3
X_d_675 _n_4 VSS FILL3
X_d_676 _n_4 VSS FILL3
X_d_677 _n_4 VSS FILL3
X_d_678 _n_4 VSS FILL3
X_d_679 _n_4 VSS FILL3
X_d_680 _n_4 VSS FILL3
X_d_681 _n_4 VSS FILL3
X_d_682 _n_4 VSS FILL3
X_d_683 _n_4 VSS FILL3
X_d_684 _n_4 VSS FILL3
X_d_685 _n_4 VSS FILL3
X_d_686 _n_4 VSS FILL3
X_d_687 _n_4 VSS FILL3
X_d_688 _n_4 VSS FILL3
X_d_689 _n_4 VSS FILL3
X_d_690 _n_4 VSS FILL3
X_d_691 _n_4 VSS FILL3
X_d_692 _n_4 VSS FILL3
X_d_693 _n_4 VSS FILL3
X_d_694 _n_4 VSS FILL3
X_d_695 _n_4 VSS FILL3
X_d_696 _n_4 VSS FILL3
X_d_697 _n_4 VSS FILL3
X_d_698 _n_4 VSS FILL3
X_d_699 _n_4 VSS FILL3
X_d_700 _n_4 VSS FILL3
X_d_701 _n_4 VSS FILL3
X_d_702 _n_4 VSS FILL3
X_d_703 _n_4 VSS FILL3
X_d_704 _n_4 VSS FILL3
X_d_705 _n_4 VSS FILL3
X_d_706 _n_4 VSS FILL3
X_d_707 _n_4 VSS FILL3
X_d_708 _n_4 VSS FILL3
X_d_709 _n_4 VSS FILL3
X_d_710 _n_4 VSS FILL3
X_d_711 _n_4 VSS FILL3
X_d_712 _n_4 VSS FILL3
X_d_713 _n_4 VSS FILL3
X_d_714 _n_4 VSS FILL3
X_d_715 _n_58 _n_72 _n_73 _n_5 _n_40 _n_4 VSS NAND4
X_d_716 _n_4 VSS FILL2
X_d_717 _n_4 VSS FILL3
X_d_718 _n_4 VSS FILL3
X_d_719 _n_4 VSS FILL3
X_d_720 _n_4 VSS FILL3
X_d_721 _n_4 VSS FILL3
X_d_722 _n_4 VSS FILL3
X_d_723 _n_4 VSS FILL3
X_d_724 _n_4 VSS FILL3
X_d_725 _n_4 VSS FILL3
X_d_726 _n_4 VSS FILL3
X_d_727 _n_4 VSS FILL3
X_d_728 _n_4 VSS FILL3
X_d_729 _n_4 VSS FILL3
X_d_730 _n_4 VSS FILL3
X_d_731 _n_4 VSS FILL3
X_d_732 _n_4 VSS FILL3
X_d_733 _n_4 VSS FILL3
X_d_734 _n_4 VSS FILL3
X_d_735 _n_4 VSS FILL3
X_d_736 _n_4 VSS FILL3
X_d_737 _n_4 VSS FILL3
X_d_738 _n_4 VSS FILL3
X_d_739 _n_4 VSS FILL3
X_d_740 _n_4 VSS FILL3
X_d_741 _n_4 VSS FILL3
X_d_742 _n_4 VSS FILL3
X_d_743 _n_4 VSS FILL3
X_d_744 _n_92 _n_6 _n_8 _n_65 _n_59 _n_4 VSS NOR4
X_d_745 _n_304 _n_317 _n_346 _n_347 _n_135 _n_4 VSS NOR4
X_d_746 _n_6 _n_50 _n_33 _n_65 _n_63 _n_4 VSS NOR4
X_d_747 _n_63 _n_41 _n_22 _n_34 _n_4 VSS NOR3
X_d_748 _n_358 _n_345 _n_317 _n_346 _n_463 _n_4 VSS NOR4
X_d_749 _n_50 _n_94 _n_8 _n_65 _n_13 _n_4 VSS NOR4
X_d_750 _n_77 _n_50 _n_51 _n_65 _n_121 _n_4 VSS NOR4
X_d_751 _n_98 _n_114 _n_99 _n_125 _n_56 _n_4 VSS NOR4
X_d_752 _n_60 _n_99 _n_118 _n_143 _n_4 VSS AND3_X1
X_d_753 _n_92 _n_94 _n_33 _n_65 _n_41 _n_4 VSS NOR4
X_d_754 _n_44 _n_13 _n_4 _n_23 VSS NOR2
X_d_755 _n_242 _n_176 _n_232 _n_159 _n_43 _n_4 VSS NOR4
X_d_756 _n_92 _n_6 _n_14 _n_33 _n_22 _n_4 VSS NOR4
X_d_757 _n_85 _n_98 _n_114 _n_86 _n_105 _n_4 VSS NOR4
X_d_758 _n_85 _n_98 _n_125 _n_60 _n_27 _n_4 VSS NOR4
X_d_759 _n_304 _n_418 _n_298 _n_347 _n_535 _n_4 VSS NOR4
X_d_760 _n_11 _n_37 _n_38 _n_27 _n_57 _n_4 VSS NOR4
X_d_761 _n_4 VSS FILL3
X_d_762 _n_28 _n_56 _n_27 _n_4 _n_72 VSS OAI21
X_d_763 _n_28 _n_57 _n_58 _n_4 VSS NAND2
X_d_764 _n_99 _n_28 _n_59 _n_38 _n_4 _n_39 VSS AOI22
X_d_765 _n_77 _n_96 _n_50 _n_51 _n_44 _n_4 VSS NOR4
X_d_766 _n_345 _n_298 _n_346 _n_347 _n_273 _n_4 VSS NOR4
X_d_767 _n_536 _n_530 _n_531 _n_578 _n_500 _n_4 VSS NOR4
X_d_768 _n_147 _n_77 _n_96 _n_51 _n_133 _n_4 VSS NOR4
X_d_769 _n_85 _n_98 _n_114 _n_125 _n_11 _n_4 VSS NOR4
X_d_770 _n_358 _n_427 _n_317 _n_346 _n_138 _n_4 VSS NOR4
X_d_771 _n_313 _n_4 _n_144 VSS BUFTH
X_d_772 _n_495 _n_4 _n_260 VSS BUFTH
X_d_773 _n_17 _n_4 _n_16 VSS BUFTH
X_d_774 _n_579 _n_4 _n_194 VSS BUFTH
X_d_775 _n_632 _n_4 _n_91 VSS BUFTH
X_d_776 _n_183 _n_4 _n_236 VSS BUFTH
X_d_777 _n_105 _n_56 _n_4 _n_37 VSS OR2
X_d_779 _n_10 _n_4 _n_164 VSS BUFTH
X_d_780 _n_85 _n_18 _n_71 _n_125 _n_38 _n_4 VSS NOR4
X_d_820 _n_529 _n_427 _n_4 _n_634 VSS OR2
X_d_821 _n_453 _n_347 _n_4 _n_403 VSS OR2
X_d_822 _n_349 _n_337 _n_4 _n_159 VSS OR2
X_d_823 _n_583 _n_445 _n_4 _n_568 VSS OR2
X_d_824 _n_155 _n_161 _n_4 _n_160 VSS OR2
X_d_825 _n_310 _n_343 _n_4 _n_316 VSS OR2
X_d_826 _n_140 _n_151 _n_4 _n_106 VSS OR2
X_d_827 _n_480 _n_473 _n_4 _n_319 VSS OR2
X_d_828 _n_503 _n_517 _n_4 _n_519 VSS OR2
X_d_829 _n_329 _n_296 _n_4 _n_342 VSS OR2
X_d_830 _n_216 _n_70 _n_4 _n_214 VSS OR2
X_d_831 _n_135 _n_216 _n_4 _n_153 VSS OR2
.ENDS c4004_core
.SUBCKT OSS_ESD_5V_VDD PAD_VDD VSS
X_d_1 VSS PAD_VDD OSS_PCH_ESD
X_d_3 PAD_VDD VSS OSS_NCH_ESD
.ENDS OSS_ESD_5V_VDD
.SUBCKT OSS_ESD_5V_VSS VDD PAD_VSS
X_d_1 VDD PAD_VSS OSS_NCH_ESD
X_d_2 PAD_VSS VDD OSS_PCH_ESD
.ENDS OSS_ESD_5V_VSS
.SUBCKT OSS_ESD_5V_DIO PAD VDD HIZ OUT VSS
X_d_1 PAD VDD _n_10 OSS_PCH_DRV
X_d_2 PAD _n_8 VSS OSS_NCH_DRV
X_d_5 OUT HIZ VDD _n_10 _n_8 VSS OSS_DRV
.ENDS OSS_ESD_5V_DIO
.SUBCKT XOR2 A Y B vdd vss
M_d_1 _n_8 _n_3 Y vdd PMOS_mst L=1u W=10.2u AS=28.56p AD=15.3p PS=26u PD=13.2u
M_d_2 vdd B _n_8 vdd PMOS_mst L=1u W=10.2u AS=15.3p AD=15.3p PS=13.2u PD=13.2u
M_d_3 _n_8 A vdd vdd PMOS_mst L=1u W=10.2u AS=15.3p AD=28.56p PS=13.2u PD=26u
M_d_4 _n_9 A vdd vdd PMOS_mst L=1u W=10.2u AS=28.56p AD=6.12p PS=26u PD=11.4u
M_d_5 _n_3 B _n_9 vdd PMOS_mst L=1u W=10.2u AS=6.12p AD=28.56p PS=11.4u PD=26u
M_d_6 vss _n_3 Y vss NMOS_mst L=1u W=3.4u AS=9.52p AD=5.1p PS=12.4u PD=6.4u
M_d_7 _n_5 B vss vss NMOS_mst L=1u W=3.4u AS=5.1p AD=2.04p PS=6.4u PD=4.6u
M_d_8 Y A _n_5 vss NMOS_mst L=1u W=3.4u AS=2.04p AD=9.52p PS=4.6u PD=12.4u
M_d_9 vss A _n_3 vss NMOS_mst L=1u W=3.4u AS=9.52p AD=5.1p PS=12.4u PD=6.4u
M_d_10 _n_3 B vss vss NMOS_mst L=1u W=3.4u AS=5.1p AD=9.52p PS=6.4u PD=12.4u
.ENDS XOR2
.SUBCKT BUFTH A vdd Y vss
M_d_1 _n_5 _n_2 vss vdd PMOS_mst L=1u W=10.2u AS=21.93p AD=21.93p PS=23.9u PD=23.9u
M_d_3 Y _n_2 vdd vdd PMOS_mst L=1u W=10.2u AS=28.56p AD=28.56p PS=26u PD=26u
M_d_4 _n_5 A _n_2 vdd PMOS_mst L=1u W=5.1u AS=14.28p AD=7.65p PS=15.8u PD=8.1u
M_d_5 vdd A _n_5 vdd PMOS_mst L=1u W=5.1u AS=7.65p AD=14.28p PS=8.1u PD=15.8u
M_d_6 Y _n_2 vss vss NMOS_mst L=1u W=3.4u AS=9.52p AD=9.52p PS=12.4u PD=12.4u
M_d_7 _n_4 A _n_2 vss NMOS_mst L=1u W=3.4u AS=9.52p AD=5.1p PS=12.4u PD=6.4u
M_d_8 vss A _n_4 vss NMOS_mst L=1u W=3.4u AS=5.1p AD=9.52p PS=6.4u PD=12.4u
M_d_9 _n_4 _n_2 vdd vss NMOS_mst L=1u W=6.8u AS=14.62p AD=14.62p PS=18.8u PD=18.8u
.ENDS BUFTH
.SUBCKT MUX2 S A B Y vdd vss
M_d_1 _n_3 S vdd vdd PMOS_mst L=1u W=5.2u AS=14.56p AD=14.56p PS=16u PD=16u
M_d_2 Y _n_6 vdd vdd PMOS_mst L=1u W=11.2u AS=31.36p AD=31.36p PS=28u PD=28u
M_d_3 _n_5 A vdd vdd PMOS_mst L=1u W=5.2u AS=14.56p AD=7.8p PS=16u PD=8.2u
M_d_4 _n_6 S _n_5 vdd PMOS_mst L=1u W=5.2u AS=7.8p AD=7.8p PS=8.2u PD=8.2u
M_d_5 _n_7 _n_3 _n_6 vdd PMOS_mst L=1u W=5.2u AS=7.8p AD=7.8p PS=8.2u PD=8.2u
M_d_6 vdd B _n_7 vdd PMOS_mst L=1u W=5.2u AS=7.8p AD=15.6p PS=8.2u PD=16.4u
M_d_7 Y _n_6 vss vss NMOS_mst L=1u W=3.4u AS=9.52p AD=9.52p PS=12.4u PD=12.4u
M_d_8 _n_5 A vss vss NMOS_mst L=1u W=3.4u AS=9.52p AD=5.1p PS=12.4u PD=6.4u
M_d_9 _n_6 _n_3 _n_5 vss NMOS_mst L=1u W=3.4u AS=5.1p AD=5.1p PS=6.4u PD=6.4u
M_d_10 _n_7 S _n_6 vss NMOS_mst L=1u W=3.4u AS=5.1p AD=5.1p PS=6.4u PD=6.4u
M_d_11 vss B _n_7 vss NMOS_mst L=1u W=3.4u AS=5.1p AD=9.52p PS=6.4u PD=12.4u
M_d_12 _n_3 S vss vss NMOS_mst L=1u W=3.4u AS=10.2p AD=9.52p PS=12.8u PD=12.4u
.ENDS MUX2
.SUBCKT OR4 C D Y A B vdd vss
M_d_1 _n_10 A _n_2 vdd PMOS_mst L=1u W=10.2u AS=28.56p AD=6.12p PS=26u PD=11.4u
M_d_2 _n_9 B _n_10 vdd PMOS_mst L=1u W=10.2u AS=6.12p AD=6.12p PS=11.4u PD=11.4u
M_d_3 _n_11 C _n_9 vdd PMOS_mst L=1u W=10.2u AS=6.12p AD=6.12p PS=11.4u PD=11.4u
M_d_4 vdd D _n_11 vdd PMOS_mst L=1u W=10.2u AS=6.12p AD=15.3p PS=11.4u PD=13.2u
M_d_5 Y _n_2 vdd vdd PMOS_mst L=1u W=10.2u AS=15.3p AD=28.56p PS=13.2u PD=26u
M_d_6 _n_2 A vss vss NMOS_mst L=1u W=3.4u AS=9.52p AD=5.1p PS=12.4u PD=6.4u
M_d_7 vss B _n_2 vss NMOS_mst L=1u W=3.4u AS=5.1p AD=5.1p PS=6.4u PD=6.4u
M_d_8 _n_2 C vss vss NMOS_mst L=1u W=3.4u AS=5.1p AD=5.1p PS=6.4u PD=6.4u
M_d_9 vss D _n_2 vss NMOS_mst L=1u W=3.4u AS=5.1p AD=5.1p PS=6.4u PD=6.4u
M_d_10 Y _n_2 vss vss NMOS_mst L=1u W=3.4u AS=5.1p AD=9.52p PS=6.4u PD=12.4u
.ENDS OR4
.SUBCKT OR3 A B C Y vdd vss
M_d_1 _n_9 A _n_4 vdd PMOS_mst L=1u W=10.2u AS=28.56p AD=6.12p PS=26u PD=11.4u
M_d_2 _n_8 B _n_9 vdd PMOS_mst L=1u W=10.2u AS=6.12p AD=6.12p PS=11.4u PD=11.4u
M_d_3 vdd C _n_8 vdd PMOS_mst L=1u W=10.2u AS=6.12p AD=15.3p PS=11.4u PD=13.2u
M_d_4 Y _n_4 vdd vdd PMOS_mst L=1u W=10.2u AS=15.3p AD=28.56p PS=13.2u PD=26u
M_d_5 vss A _n_4 vss NMOS_mst L=1u W=3.4u AS=9.52p AD=5.1p PS=12.4u PD=6.4u
M_d_6 _n_4 B vss vss NMOS_mst L=1u W=3.4u AS=5.1p AD=5.1p PS=6.4u PD=6.4u
M_d_7 vss C _n_4 vss NMOS_mst L=1u W=3.4u AS=5.1p AD=5.1p PS=6.4u PD=6.4u
M_d_8 Y _n_4 vss vss NMOS_mst L=1u W=3.4u AS=5.1p AD=9.52p PS=6.4u PD=12.4u
.ENDS OR3
.SUBCKT AND4_X1 Y A B C D vdd vss
M_d_1 Y _n_2 vdd vdd PMOS_mst L=1u W=10.2u AS=28.56p AD=28.56p PS=26u PD=26u
M_d_2 _n_2 A vdd vdd PMOS_mst L=1u W=10.2u AS=28.56p AD=15.3p PS=26u PD=13.2u
M_d_3 vdd B _n_2 vdd PMOS_mst L=1u W=10.2u AS=15.3p AD=15.3p PS=13.2u PD=13.2u
M_d_4 _n_2 C vdd vdd PMOS_mst L=1u W=10.2u AS=15.3p AD=15.3p PS=13.2u PD=13.2u
M_d_5 vdd D _n_2 vdd PMOS_mst L=1u W=10.2u AS=15.3p AD=29.58p PS=13.2u PD=26.2u
M_d_6 Y _n_2 vss vss NMOS_mst L=1u W=3.4u AS=9.52p AD=9.52p PS=12.4u PD=12.4u
M_d_7 _n_4 A vss vss NMOS_mst L=1u W=3.4u AS=9.52p AD=2.04p PS=12.4u PD=4.6u
M_d_8 _n_5 B _n_4 vss NMOS_mst L=1u W=3.4u AS=2.04p AD=2.04p PS=4.6u PD=4.6u
M_d_9 _n_6 C _n_5 vss NMOS_mst L=1u W=3.4u AS=2.04p AD=2.04p PS=4.6u PD=4.6u
M_d_10 _n_2 D _n_6 vss NMOS_mst L=1u W=3.4u AS=2.04p AD=9.52p PS=4.6u PD=12.4u
.ENDS AND4_X1
.SUBCKT XNOR2 A Y B vdd vss
M_d_1 vdd _n_3 Y vdd PMOS_mst L=1u W=10.2u AS=28.56p AD=15.3p PS=26u PD=13.2u
M_d_2 _n_9 B vdd vdd PMOS_mst L=1u W=10.2u AS=15.3p AD=6.12p PS=13.2u PD=11.4u
M_d_3 Y A _n_9 vdd PMOS_mst L=1u W=10.2u AS=6.12p AD=28.56p PS=11.4u PD=26u
M_d_4 vdd A _n_3 vdd PMOS_mst L=1u W=10.2u AS=28.56p AD=15.3p PS=26u PD=13.2u
M_d_5 _n_3 B vdd vdd PMOS_mst L=1u W=10.2u AS=15.3p AD=28.56p PS=13.2u PD=26u
M_d_6 _n_5 _n_3 Y vss NMOS_mst L=1u W=3.4u AS=9.52p AD=5.1p PS=12.4u PD=6.4u
M_d_7 vss B _n_5 vss NMOS_mst L=1u W=3.4u AS=5.1p AD=5.1p PS=6.4u PD=6.4u
M_d_8 _n_5 A vss vss NMOS_mst L=1u W=3.4u AS=5.1p AD=9.52p PS=6.4u PD=12.4u
M_d_9 _n_6 A vss vss NMOS_mst L=1u W=3.4u AS=9.52p AD=2.04p PS=12.4u PD=4.6u
M_d_10 _n_3 B _n_6 vss NMOS_mst L=1u W=3.4u AS=2.04p AD=9.52p PS=4.6u PD=12.4u
.ENDS XNOR2
.SUBCKT BUF_X2 A vdd Y vss
M_d_1 vdd A _n_3 vdd PMOS_mst L=1u W=10.2u AS=28.56p AD=15.3p PS=26u PD=13.2u
M_d_2 Y _n_3 vdd vdd PMOS_mst L=1u W=20.4u AS=30.6p AD=43.86p PS=26.4u PD=39.2u
M_d_4 vss A _n_3 vss NMOS_mst L=1u W=3.4u AS=9.52p AD=5.1p PS=12.4u PD=6.4u
M_d_5 Y _n_3 vss vss NMOS_mst L=1u W=6.8u AS=10.2p AD=14.62p PS=12.8u PD=18.8u
.ENDS BUF_X2
.SUBCKT FILL2 vdd vss
M_d_1 vdd vss vdd vdd PMOS_mst L=3.2u W=15.8u AS=44.24p AD=44.24p PS=37.2u PD=37.2u
M_d_2 vss vdd vss vss NMOS_mst L=3.2u W=13.1u AS=36.68p AD=36.68p PS=31.8u PD=31.8u
.ENDS FILL2
.SUBCKT AND2_X1 A B vdd Y vss
M_d_1 _n_3 A vdd vdd PMOS_mst L=1u W=10.2u AS=28.56p AD=15.3p PS=26u PD=13.2u
M_d_2 vdd B _n_3 vdd PMOS_mst L=1u W=10.2u AS=15.3p AD=15.3p PS=13.2u PD=13.2u
M_d_3 Y _n_3 vdd vdd PMOS_mst L=1u W=10.2u AS=15.3p AD=28.56p PS=13.2u PD=26u
M_d_4 _n_7 A vss vss NMOS_mst L=1u W=3.4u AS=9.52p AD=2.04p PS=12.4u PD=4.6u
M_d_5 _n_3 B _n_7 vss NMOS_mst L=1u W=3.4u AS=2.04p AD=9.52p PS=4.6u PD=12.4u
M_d_6 Y _n_3 vss vss NMOS_mst L=1u W=3.4u AS=35.36p AD=9.52p PS=27.6u PD=12.4u
.ENDS AND2_X1
.SUBCKT NOR4 A B C D Y vdd vss
M_d_1 _n_10 A vdd vdd PMOS_mst L=1u W=10.2u AS=28.56p AD=6.12p PS=26u PD=11.4u
M_d_2 _n_9 B _n_10 vdd PMOS_mst L=1u W=10.2u AS=6.12p AD=6.12p PS=11.4u PD=11.4u
M_d_3 _n_8 C _n_9 vdd PMOS_mst L=1u W=10.2u AS=6.12p AD=6.12p PS=11.4u PD=11.4u
M_d_4 Y D _n_8 vdd PMOS_mst L=1u W=10.2u AS=6.12p AD=28.56p PS=11.4u PD=26u
M_d_5 Y A vss vss NMOS_mst L=1u W=3.4u AS=9.52p AD=5.1p PS=12.4u PD=6.4u
M_d_6 vss B Y vss NMOS_mst L=1u W=3.4u AS=5.1p AD=5.1p PS=6.4u PD=6.4u
M_d_7 Y C vss vss NMOS_mst L=1u W=3.4u AS=5.1p AD=5.1p PS=6.4u PD=6.4u
M_d_8 vss D Y vss NMOS_mst L=1u W=3.4u AS=5.1p AD=9.52p PS=6.4u PD=12.4u
.ENDS NOR4
.SUBCKT NAND4 A B C D Y vdd vss
M_d_1 Y A vdd vdd PMOS_mst L=1u W=10.2u AS=28.56p AD=15.3p PS=26u PD=13.2u
M_d_2 vdd B Y vdd PMOS_mst L=1u W=10.2u AS=15.3p AD=15.3p PS=13.2u PD=13.2u
M_d_3 Y C vdd vdd PMOS_mst L=1u W=10.2u AS=15.3p AD=15.3p PS=13.2u PD=13.2u
M_d_4 vdd D Y vdd PMOS_mst L=1u W=10.2u AS=15.3p AD=29.58p PS=13.2u PD=26.2u
M_d_5 _n_10 A vss vss NMOS_mst L=1u W=3.4u AS=9.52p AD=2.04p PS=12.4u PD=4.6u
M_d_6 _n_9 B _n_10 vss NMOS_mst L=1u W=3.4u AS=2.04p AD=2.04p PS=4.6u PD=4.6u
M_d_7 _n_8 C _n_9 vss NMOS_mst L=1u W=3.4u AS=2.04p AD=2.04p PS=4.6u PD=4.6u
M_d_8 Y D _n_8 vss NMOS_mst L=1u W=3.4u AS=2.04p AD=9.52p PS=4.6u PD=12.4u
.ENDS NAND4
.SUBCKT INV_X1 A vdd Y vss
M_d_1 Y A vdd vdd PMOS_mst L=1u W=10.2u AS=28.56p AD=28.56p PS=26u PD=26u
M_d_2 Y A vss vss NMOS_mst L=1u W=3.4u AS=9.52p AD=9.52p PS=12.4u PD=12.4u
.ENDS INV_X1
.SUBCKT NOR3 A B C Y vdd vss
M_d_1 _n_8 A vdd vdd PMOS_mst L=1u W=10.2u AS=28.56p AD=6.12p PS=26u PD=11.4u
M_d_2 _n_7 B _n_8 vdd PMOS_mst L=1u W=10.2u AS=6.12p AD=6.12p PS=11.4u PD=11.4u
M_d_3 Y C _n_7 vdd PMOS_mst L=1u W=10.2u AS=6.12p AD=28.56p PS=11.4u PD=26u
M_d_4 Y A vss vss NMOS_mst L=1u W=3.4u AS=9.52p AD=5.1p PS=12.4u PD=6.4u
M_d_5 vss B Y vss NMOS_mst L=1u W=3.4u AS=5.1p AD=5.1p PS=6.4u PD=6.4u
M_d_6 Y C vss vss NMOS_mst L=1u W=3.4u AS=5.1p AD=9.52p PS=6.4u PD=12.4u
.ENDS NOR3
.SUBCKT OR2 B A vdd Y vss
M_d_1 _n_7 A _n_3 vdd PMOS_mst L=1u W=10.2u AS=28.56p AD=6.12p PS=26u PD=11.4u
M_d_2 vdd B _n_7 vdd PMOS_mst L=1u W=10.2u AS=6.12p AD=15.3p PS=11.4u PD=13.2u
M_d_3 Y _n_3 vdd vdd PMOS_mst L=1u W=10.2u AS=15.3p AD=28.56p PS=13.2u PD=26u
M_d_4 _n_3 A vss vss NMOS_mst L=1u W=3.4u AS=9.52p AD=5.1p PS=12.4u PD=6.4u
M_d_5 vss B _n_3 vss NMOS_mst L=1u W=3.4u AS=5.1p AD=5.1p PS=6.4u PD=6.4u
M_d_6 Y _n_3 vss vss NMOS_mst L=1u W=3.4u AS=5.1p AD=9.52p PS=6.4u PD=12.4u
.ENDS OR2
.SUBCKT NAND2 A B Y vdd vss
M_d_1 Y A vdd vdd PMOS_mst L=1u W=10.2u AS=28.56p AD=15.3p PS=26u PD=13.2u
M_d_2 vdd B Y vdd PMOS_mst L=1u W=10.2u AS=15.3p AD=28.56p PS=13.2u PD=26u
M_d_3 _n_6 A vss vss NMOS_mst L=1u W=3.4u AS=9.52p AD=2.04p PS=12.4u PD=4.6u
M_d_4 Y B _n_6 vss NMOS_mst L=1u W=3.4u AS=2.04p AD=9.52p PS=4.6u PD=12.4u
.ENDS NAND2
.SUBCKT OAI22 B2 A1 A2 B1 vdd Y vss
M_d_1 _n_10 A1 vdd vdd PMOS_mst L=1u W=10.2u AS=28.56p AD=6.12p PS=26u PD=11.4u
M_d_2 Y A2 _n_10 vdd PMOS_mst L=1u W=10.2u AS=6.12p AD=15.3p PS=11.4u PD=13.2u
M_d_3 _n_9 B1 Y vdd PMOS_mst L=1u W=10.2u AS=15.3p AD=6.12p PS=13.2u PD=11.4u
M_d_4 vdd B2 _n_9 vdd PMOS_mst L=1u W=10.2u AS=6.12p AD=28.56p PS=11.4u PD=26u
M_d_5 _n_7 A1 vss vss NMOS_mst L=1u W=3.4u AS=9.52p AD=5.1p PS=12.4u PD=6.4u
M_d_6 vss A2 _n_7 vss NMOS_mst L=1u W=3.4u AS=5.1p AD=9.52p PS=6.4u PD=12.4u
M_d_7 Y B1 _n_7 vss NMOS_mst L=1u W=3.4u AS=9.52p AD=5.1p PS=12.4u PD=6.4u
M_d_8 _n_7 B2 Y vss NMOS_mst L=1u W=3.4u AS=5.1p AD=18.7p PS=6.4u PD=17.8u
.ENDS OAI22
.SUBCKT NOR2 A B vdd Y vss
M_d_1 _n_6 A vdd vdd PMOS_mst L=1u W=10.2u AS=28.56p AD=6.12p PS=26u PD=11.4u
M_d_2 Y B _n_6 vdd PMOS_mst L=1u W=10.2u AS=6.12p AD=28.56p PS=11.4u PD=26u
M_d_3 Y A vss vss NMOS_mst L=1u W=3.4u AS=9.52p AD=5.1p PS=12.4u PD=6.4u
M_d_4 vss B Y vss NMOS_mst L=1u W=3.4u AS=5.1p AD=9.52p PS=6.4u PD=12.4u
.ENDS NOR2
.SUBCKT SRAM128 VDD WR A0 A4 A1 A2 CE A3 DIN[0] DO[0] DIN[1] DO[1] DIN[2] DO[2] DIN[3] DO[3] VSS
M_d_1 VDD A0 A0n VDD PMOS_mst L=1u W=5.4u AS=15.12p AD=8.1p PS=16.4u PD=8.4u
M_d_2 A0p A0n VDD VDD PMOS_mst L=1u W=5.4u AS=8.1p AD=15.12p PS=8.4u PD=16.4u
M_d_3 PR0 _n_10 VDD VDD PMOS_mst L=1u W=6.8u AS=14.62p AD=14.62p PS=18.8u PD=18.8u
M_d_5 VDD _n_11 _n_8 VDD PMOS_mst L=1u W=5.4u AS=15.12p AD=8.1p PS=16.4u PD=8.4u
M_d_6 _n_11 A4 VDD VDD PMOS_mst L=1u W=5.4u AS=8.1p AD=15.12p PS=8.4u PD=16.4u
M_d_7 VDD _n_15 _n_10 VDD PMOS_mst L=1u W=3.4u AS=9.52p AD=5.1p PS=12.4u PD=6.4u
M_d_8 _n_19 _n_15 VDD VDD PMOS_mst L=1u W=3.4u AS=5.1p AD=9.52p PS=6.4u PD=12.4u
M_d_9 VDD A1 A1n VDD PMOS_mst L=1u W=5.4u AS=15.12p AD=8.1p PS=16.4u PD=8.4u
M_d_10 A1p A1n VDD VDD PMOS_mst L=1u W=5.4u AS=8.1p AD=15.12p PS=8.4u PD=16.4u
M_d_11 PR1 _n_19 VDD VDD PMOS_mst L=1u W=6.8u AS=14.62p AD=14.62p PS=18.8u PD=18.8u
M_d_13 VDD _n_20 _n_15 VDD PMOS_mst L=1u W=3.4u AS=9.52p AD=5.1p PS=12.4u PD=6.4u
M_d_14 _n_20 CE VDD VDD PMOS_mst L=1u W=3.4u AS=5.1p AD=9.52p PS=6.4u PD=12.4u
M_d_15 VDD A2 A2n VDD PMOS_mst L=1u W=5.4u AS=15.12p AD=8.1p PS=16.4u PD=8.4u
M_d_16 A2p A2n VDD VDD PMOS_mst L=1u W=5.4u AS=8.1p AD=15.12p PS=8.4u PD=16.4u
M_d_17 PRn _n_46 VDD VDD PMOS_mst L=1u W=6.8u AS=14.62p AD=10.2p PS=18.8u PD=12.8u
M_d_19 PRn _n_64 VDD VDD PMOS_mst L=1u W=6.8u AS=10.2p AD=13.6p PS=12.8u PD=14.8u
M_d_21 LATp _n_229 VDD VDD PMOS_mst L=1u W=6.8u AS=13.6p AD=10.2p PS=14.8u PD=12.8u
M_d_23 LATp PRn VDD VDD PMOS_mst L=1u W=6.8u AS=10.2p AD=14.62p PS=12.8u PD=18.8u
M_d_25 VDD _n_46 _n_47 VDD PMOS_mst L=1u W=3.4u AS=9.52p AD=9.52p PS=12.4u PD=12.4u
M_d_26 VDD _n_46 CE_CEp VDD PMOS_mst L=1u W=3.4u AS=9.52p AD=9.52p PS=12.4u PD=12.4u
M_d_27 VDD CE _n_46 VDD PMOS_mst L=1u W=3.4u AS=9.52p AD=9.52p PS=12.4u PD=12.4u
M_d_28 VDD A3 A3n VDD PMOS_mst L=1u W=5.4u AS=15.12p AD=8.1p PS=16.4u PD=8.4u
M_d_29 A3p A3n VDD VDD PMOS_mst L=1u W=5.4u AS=8.1p AD=15.12p PS=8.4u PD=16.4u
M_d_30 VDD _n_47 VDD VDD PMOS_mst L=6u W=3.4u AS=19.72p AD=5.1p PS=18.4u PD=6.4u
M_d_31 VDD _n_231 VDD VDD PMOS_mst L=4.2u W=3.4u AS=5.1p AD=25.16p PS=6.4u PD=21.6u
M_d_32 VDD PR0 _n_29 VDD PMOS_mst L=1u W=3.4u AS=9.52p AD=5.1p PS=12.4u PD=6.4u
M_d_33 _n_197 _n_29 VDD VDD PMOS_mst L=1u W=13.6u AS=20.4p AD=24.82p PS=25.6u PD=31.6u
M_d_37 VDD PR0 _n_48 VDD PMOS_mst L=1u W=3.4u AS=9.52p AD=5.1p PS=12.4u PD=6.4u
M_d_38 _n_198 _n_48 VDD VDD PMOS_mst L=1u W=13.6u AS=20.4p AD=24.82p PS=25.6u PD=31.6u
M_d_42 VDD PR0 _n_30 VDD PMOS_mst L=1u W=3.4u AS=9.52p AD=5.1p PS=12.4u PD=6.4u
M_d_43 _n_199 _n_30 VDD VDD PMOS_mst L=1u W=13.6u AS=20.4p AD=24.82p PS=25.6u PD=31.6u
M_d_47 VDD PR0 _n_49 VDD PMOS_mst L=1u W=3.4u AS=9.52p AD=5.1p PS=12.4u PD=6.4u
M_d_48 _n_200 _n_49 VDD VDD PMOS_mst L=1u W=13.6u AS=20.4p AD=24.82p PS=25.6u PD=31.6u
M_d_52 VDD PR0 _n_31 VDD PMOS_mst L=1u W=3.4u AS=9.52p AD=5.1p PS=12.4u PD=6.4u
M_d_53 _n_201 _n_31 VDD VDD PMOS_mst L=1u W=13.6u AS=20.4p AD=24.82p PS=25.6u PD=31.6u
M_d_57 VDD PR0 _n_50 VDD PMOS_mst L=1u W=3.4u AS=9.52p AD=5.1p PS=12.4u PD=6.4u
M_d_58 _n_202 _n_50 VDD VDD PMOS_mst L=1u W=13.6u AS=20.4p AD=24.82p PS=25.6u PD=31.6u
M_d_62 VDD PR0 _n_32 VDD PMOS_mst L=1u W=3.4u AS=9.52p AD=5.1p PS=12.4u PD=6.4u
M_d_63 _n_203 _n_32 VDD VDD PMOS_mst L=1u W=13.6u AS=20.4p AD=24.82p PS=25.6u PD=31.6u
M_d_67 VDD PR0 _n_51 VDD PMOS_mst L=1u W=3.4u AS=9.52p AD=5.1p PS=12.4u PD=6.4u
M_d_68 _n_204 _n_51 VDD VDD PMOS_mst L=1u W=13.6u AS=20.4p AD=24.82p PS=25.6u PD=31.6u
M_d_72 VDD PR0 _n_33 VDD PMOS_mst L=1u W=3.4u AS=9.52p AD=5.1p PS=12.4u PD=6.4u
M_d_73 _n_205 _n_33 VDD VDD PMOS_mst L=1u W=13.6u AS=20.4p AD=24.82p PS=25.6u PD=31.6u
M_d_77 VDD PR0 _n_52 VDD PMOS_mst L=1u W=3.4u AS=9.52p AD=5.1p PS=12.4u PD=6.4u
M_d_78 _n_206 _n_52 VDD VDD PMOS_mst L=1u W=13.6u AS=20.4p AD=24.82p PS=25.6u PD=31.6u
M_d_82 VDD PR0 _n_34 VDD PMOS_mst L=1u W=3.4u AS=9.52p AD=5.1p PS=12.4u PD=6.4u
M_d_83 _n_207 _n_34 VDD VDD PMOS_mst L=1u W=13.6u AS=20.4p AD=24.82p PS=25.6u PD=31.6u
M_d_87 VDD PR0 _n_53 VDD PMOS_mst L=1u W=3.4u AS=9.52p AD=5.1p PS=12.4u PD=6.4u
M_d_88 _n_208 _n_53 VDD VDD PMOS_mst L=1u W=13.6u AS=20.4p AD=24.82p PS=25.6u PD=31.6u
M_d_92 VDD PR0 _n_35 VDD PMOS_mst L=1u W=3.4u AS=9.52p AD=5.1p PS=12.4u PD=6.4u
M_d_93 _n_209 _n_35 VDD VDD PMOS_mst L=1u W=13.6u AS=20.4p AD=24.82p PS=25.6u PD=31.6u
M_d_97 VDD PR0 _n_54 VDD PMOS_mst L=1u W=3.4u AS=9.52p AD=5.1p PS=12.4u PD=6.4u
M_d_98 _n_210 _n_54 VDD VDD PMOS_mst L=1u W=13.6u AS=20.4p AD=24.82p PS=25.6u PD=31.6u
M_d_102 VDD PR0 _n_36 VDD PMOS_mst L=1u W=3.4u AS=9.52p AD=5.1p PS=12.4u PD=6.4u
M_d_103 _n_211 _n_36 VDD VDD PMOS_mst L=1u W=13.6u AS=20.4p AD=24.82p PS=25.6u PD=31.6u
M_d_107 VDD PR0 _n_55 VDD PMOS_mst L=1u W=3.4u AS=9.52p AD=5.1p PS=12.4u PD=6.4u
M_d_108 _n_212 _n_55 VDD VDD PMOS_mst L=1u W=13.6u AS=20.4p AD=24.82p PS=25.6u PD=31.6u
M_d_112 VDD PR1 _n_37 VDD PMOS_mst L=1u W=3.4u AS=9.52p AD=5.1p PS=12.4u PD=6.4u
M_d_113 _n_213 _n_37 VDD VDD PMOS_mst L=1u W=13.6u AS=20.4p AD=24.82p PS=25.6u PD=31.6u
M_d_117 VDD PR1 _n_56 VDD PMOS_mst L=1u W=3.4u AS=9.52p AD=5.1p PS=12.4u PD=6.4u
M_d_118 _n_214 _n_56 VDD VDD PMOS_mst L=1u W=13.6u AS=20.4p AD=24.82p PS=25.6u PD=31.6u
M_d_122 VDD PR1 _n_38 VDD PMOS_mst L=1u W=3.4u AS=9.52p AD=5.1p PS=12.4u PD=6.4u
M_d_123 _n_215 _n_38 VDD VDD PMOS_mst L=1u W=13.6u AS=20.4p AD=24.82p PS=25.6u PD=31.6u
M_d_127 VDD PR1 _n_57 VDD PMOS_mst L=1u W=3.4u AS=9.52p AD=5.1p PS=12.4u PD=6.4u
M_d_128 _n_216 _n_57 VDD VDD PMOS_mst L=1u W=13.6u AS=20.4p AD=24.82p PS=25.6u PD=31.6u
M_d_132 VDD PR1 _n_39 VDD PMOS_mst L=1u W=3.4u AS=9.52p AD=5.1p PS=12.4u PD=6.4u
M_d_133 _n_217 _n_39 VDD VDD PMOS_mst L=1u W=13.6u AS=20.4p AD=24.82p PS=25.6u PD=31.6u
M_d_137 VDD PR1 _n_58 VDD PMOS_mst L=1u W=3.4u AS=9.52p AD=5.1p PS=12.4u PD=6.4u
M_d_138 _n_218 _n_58 VDD VDD PMOS_mst L=1u W=13.6u AS=20.4p AD=24.82p PS=25.6u PD=31.6u
M_d_142 VDD PR1 _n_40 VDD PMOS_mst L=1u W=3.4u AS=9.52p AD=5.1p PS=12.4u PD=6.4u
M_d_143 _n_219 _n_40 VDD VDD PMOS_mst L=1u W=13.6u AS=20.4p AD=24.82p PS=25.6u PD=31.6u
M_d_147 VDD PR1 _n_59 VDD PMOS_mst L=1u W=3.4u AS=9.52p AD=5.1p PS=12.4u PD=6.4u
M_d_148 _n_220 _n_59 VDD VDD PMOS_mst L=1u W=13.6u AS=20.4p AD=24.82p PS=25.6u PD=31.6u
M_d_152 VDD PR1 _n_41 VDD PMOS_mst L=1u W=3.4u AS=9.52p AD=5.1p PS=12.4u PD=6.4u
M_d_153 _n_221 _n_41 VDD VDD PMOS_mst L=1u W=13.6u AS=20.4p AD=24.82p PS=25.6u PD=31.6u
M_d_157 VDD PR1 _n_60 VDD PMOS_mst L=1u W=3.4u AS=9.52p AD=5.1p PS=12.4u PD=6.4u
M_d_158 _n_222 _n_60 VDD VDD PMOS_mst L=1u W=13.6u AS=20.4p AD=24.82p PS=25.6u PD=31.6u
M_d_162 VDD PR1 _n_42 VDD PMOS_mst L=1u W=3.4u AS=9.52p AD=5.1p PS=12.4u PD=6.4u
M_d_163 _n_223 _n_42 VDD VDD PMOS_mst L=1u W=13.6u AS=20.4p AD=24.82p PS=25.6u PD=31.6u
M_d_167 VDD PR1 _n_61 VDD PMOS_mst L=1u W=3.4u AS=9.52p AD=5.1p PS=12.4u PD=6.4u
M_d_168 _n_224 _n_61 VDD VDD PMOS_mst L=1u W=13.6u AS=20.4p AD=24.82p PS=25.6u PD=31.6u
M_d_172 VDD PR1 _n_43 VDD PMOS_mst L=1u W=3.4u AS=9.52p AD=5.1p PS=12.4u PD=6.4u
M_d_173 _n_225 _n_43 VDD VDD PMOS_mst L=1u W=13.6u AS=20.4p AD=24.82p PS=25.6u PD=31.6u
M_d_177 VDD PR1 _n_62 VDD PMOS_mst L=1u W=3.4u AS=9.52p AD=5.1p PS=12.4u PD=6.4u
M_d_178 _n_226 _n_62 VDD VDD PMOS_mst L=1u W=13.6u AS=20.4p AD=24.82p PS=25.6u PD=31.6u
M_d_182 VDD PR1 _n_44 VDD PMOS_mst L=1u W=3.4u AS=9.52p AD=5.1p PS=12.4u PD=6.4u
M_d_183 _n_227 _n_44 VDD VDD PMOS_mst L=1u W=13.6u AS=20.4p AD=24.82p PS=25.6u PD=31.6u
M_d_187 VDD PR1 _n_63 VDD PMOS_mst L=1u W=3.4u AS=9.52p AD=5.1p PS=12.4u PD=6.4u
M_d_188 _n_228 _n_63 VDD VDD PMOS_mst L=1u W=13.6u AS=20.4p AD=24.82p PS=25.6u PD=31.6u
M_d_192 VDD _n_47 _n_64 VDD PMOS_mst L=2u W=3.4u AS=9.52p AD=5.1p PS=12.4u PD=6.4u
M_d_193 _n_232 _n_231 VDD VDD PMOS_mst L=2u W=3.4u AS=5.1p AD=9.52p PS=6.4u PD=12.4u
M_d_194 VDD CE_CEp _n_162 VDD PMOS_mst L=1u W=3.4u AS=9.52p AD=5.1p PS=12.4u PD=6.4u
M_d_195 _n_233 _n_162 VDD VDD PMOS_mst L=1u W=3.4u AS=5.1p AD=9.52p PS=6.4u PD=12.4u
M_d_196 WRn WRp VDD VDD PMOS_mst L=1u W=6.8u AS=14.62p AD=14.62p PS=18.8u PD=18.8u
M_d_198 WRp _n_234 VDD VDD PMOS_mst L=1u W=6.8u AS=14.62p AD=14.62p PS=18.8u PD=18.8u
M_d_200 _n_234 _n_233 VDD VDD PMOS_mst L=1u W=3.4u AS=9.52p AD=5.1p PS=12.4u PD=6.4u
M_d_201 VDD WR _n_234 VDD PMOS_mst L=1u W=3.4u AS=5.1p AD=9.52p PS=6.4u PD=12.4u
M_d_202 _n_238 _n_275 VDD VDD PMOS_mst L=1u W=6.8u AS=14.62p AD=10.2p PS=18.8u PD=12.8u
M_d_204 _n_275 DIN[0] VDD VDD PMOS_mst L=1u W=6.8u AS=10.2p AD=14.62p PS=12.8u PD=18.8u
M_d_206 _n_231 PRn VDD VDD PMOS_mst L=1u W=3.4u AS=9.52p AD=9.52p PS=12.4u PD=12.4u
M_d_207 _n_272 LATp VDD VDD PMOS_mst L=1u W=6.8u AS=19.04p AD=14.53p PS=24.8u PD=18.449u
M_d_208 VDD _n_313 _n_272 VDD PMOS_mst L=1u W=3.4u AS=5.1p AD=5.1p PS=6.4u PD=6.4u
M_d_209 _n_313 _n_272 VDD VDD PMOS_mst L=1u W=3.4u AS=5.1p AD=5.1p PS=6.4u PD=6.4u
M_d_210 VDD LATp _n_313 VDD PMOS_mst L=1u W=6.8u AS=14.53p AD=19.04p PS=18.449u PD=24.8u
M_d_212 _n_273 _n_272 VDD VDD PMOS_mst L=1u W=10.8u AS=23.22p AD=16.2p PS=24.8u PD=16.8u
M_d_214 DO[0] _n_313 VDD VDD PMOS_mst L=1u W=10.8u AS=16.2p AD=23.22p PS=16.8u PD=24.8u
M_d_216 _n_237 _n_232 VDD VDD PMOS_mst L=1u W=3.4u AS=9.52p AD=2.04p PS=12.4u PD=4.6u
M_d_217 _n_229 WR _n_237 VDD PMOS_mst L=1u W=3.4u AS=2.04p AD=9.52p PS=4.6u PD=12.4u
M_d_218 _n_292 WRn BLn[0] VDD PMOS_mst L=1u W=9.4u AS=26.32p AD=5.64p PS=24.4u PD=10.6u
M_d_219 VDD _n_238 _n_292 VDD PMOS_mst L=1u W=9.4u AS=5.64p AD=14.1p PS=10.6u PD=12.4u
M_d_220 _n_315 _n_275 VDD VDD PMOS_mst L=1u W=9.4u AS=14.1p AD=5.64p PS=12.4u PD=10.6u
M_d_221 BLp[0] WRn _n_315 VDD PMOS_mst L=1u W=9.4u AS=5.64p AD=26.32p PS=10.6u PD=24.4u
M_d_222 VDD _n_297 _n_242 VDD PMOS_mst L=1u W=3.4u AS=9.52p AD=5.1p PS=12.4u PD=6.4u
M_d_223 _n_297 _n_242 VDD VDD PMOS_mst L=1u W=3.4u AS=5.1p AD=9.52p PS=6.4u PD=12.4u
M_d_224 VDD _n_277 _n_243 VDD PMOS_mst L=1u W=3.4u AS=9.52p AD=5.1p PS=12.4u PD=6.4u
M_d_225 _n_277 _n_243 VDD VDD PMOS_mst L=1u W=3.4u AS=5.1p AD=9.52p PS=6.4u PD=12.4u
M_d_226 VDD _n_298 _n_244 VDD PMOS_mst L=1u W=3.4u AS=9.52p AD=5.1p PS=12.4u PD=6.4u
M_d_227 _n_298 _n_244 VDD VDD PMOS_mst L=1u W=3.4u AS=5.1p AD=9.52p PS=6.4u PD=12.4u
M_d_228 VDD _n_278 _n_245 VDD PMOS_mst L=1u W=3.4u AS=9.52p AD=5.1p PS=12.4u PD=6.4u
M_d_229 _n_278 _n_245 VDD VDD PMOS_mst L=1u W=3.4u AS=5.1p AD=9.52p PS=6.4u PD=12.4u
M_d_230 VDD _n_299 _n_246 VDD PMOS_mst L=1u W=3.4u AS=9.52p AD=5.1p PS=12.4u PD=6.4u
M_d_231 _n_299 _n_246 VDD VDD PMOS_mst L=1u W=3.4u AS=5.1p AD=9.52p PS=6.4u PD=12.4u
M_d_232 VDD _n_279 _n_247 VDD PMOS_mst L=1u W=3.4u AS=9.52p AD=5.1p PS=12.4u PD=6.4u
M_d_233 _n_279 _n_247 VDD VDD PMOS_mst L=1u W=3.4u AS=5.1p AD=9.52p PS=6.4u PD=12.4u
M_d_234 VDD _n_300 _n_248 VDD PMOS_mst L=1u W=3.4u AS=9.52p AD=5.1p PS=12.4u PD=6.4u
M_d_235 _n_300 _n_248 VDD VDD PMOS_mst L=1u W=3.4u AS=5.1p AD=9.52p PS=6.4u PD=12.4u
M_d_236 VDD _n_280 _n_249 VDD PMOS_mst L=1u W=3.4u AS=9.52p AD=5.1p PS=12.4u PD=6.4u
M_d_237 _n_280 _n_249 VDD VDD PMOS_mst L=1u W=3.4u AS=5.1p AD=9.52p PS=6.4u PD=12.4u
M_d_238 VDD _n_301 _n_250 VDD PMOS_mst L=1u W=3.4u AS=9.52p AD=5.1p PS=12.4u PD=6.4u
M_d_239 _n_301 _n_250 VDD VDD PMOS_mst L=1u W=3.4u AS=5.1p AD=9.52p PS=6.4u PD=12.4u
M_d_240 VDD _n_281 _n_251 VDD PMOS_mst L=1u W=3.4u AS=9.52p AD=5.1p PS=12.4u PD=6.4u
M_d_241 _n_281 _n_251 VDD VDD PMOS_mst L=1u W=3.4u AS=5.1p AD=9.52p PS=6.4u PD=12.4u
M_d_242 VDD _n_302 _n_252 VDD PMOS_mst L=1u W=3.4u AS=9.52p AD=5.1p PS=12.4u PD=6.4u
M_d_243 _n_302 _n_252 VDD VDD PMOS_mst L=1u W=3.4u AS=5.1p AD=9.52p PS=6.4u PD=12.4u
M_d_244 VDD _n_304 _n_256 VDD PMOS_mst L=1u W=3.4u AS=9.52p AD=5.1p PS=12.4u PD=6.4u
M_d_245 _n_304 _n_256 VDD VDD PMOS_mst L=1u W=3.4u AS=5.1p AD=9.52p PS=6.4u PD=12.4u
M_d_246 VDD _n_284 _n_257 VDD PMOS_mst L=1u W=3.4u AS=9.52p AD=5.1p PS=12.4u PD=6.4u
M_d_247 _n_284 _n_257 VDD VDD PMOS_mst L=1u W=3.4u AS=5.1p AD=9.52p PS=6.4u PD=12.4u
M_d_248 VDD _n_305 _n_258 VDD PMOS_mst L=1u W=3.4u AS=9.52p AD=5.1p PS=12.4u PD=6.4u
M_d_249 _n_305 _n_258 VDD VDD PMOS_mst L=1u W=3.4u AS=5.1p AD=9.52p PS=6.4u PD=12.4u
M_d_250 VDD _n_285 _n_259 VDD PMOS_mst L=1u W=3.4u AS=9.52p AD=5.1p PS=12.4u PD=6.4u
M_d_251 _n_285 _n_259 VDD VDD PMOS_mst L=1u W=3.4u AS=5.1p AD=9.52p PS=6.4u PD=12.4u
M_d_252 VDD _n_306 _n_260 VDD PMOS_mst L=1u W=3.4u AS=9.52p AD=5.1p PS=12.4u PD=6.4u
M_d_253 _n_306 _n_260 VDD VDD PMOS_mst L=1u W=3.4u AS=5.1p AD=9.52p PS=6.4u PD=12.4u
M_d_254 VDD _n_286 _n_261 VDD PMOS_mst L=1u W=3.4u AS=9.52p AD=5.1p PS=12.4u PD=6.4u
M_d_255 _n_286 _n_261 VDD VDD PMOS_mst L=1u W=3.4u AS=5.1p AD=9.52p PS=6.4u PD=12.4u
M_d_256 VDD _n_307 _n_262 VDD PMOS_mst L=1u W=3.4u AS=9.52p AD=5.1p PS=12.4u PD=6.4u
M_d_257 _n_307 _n_262 VDD VDD PMOS_mst L=1u W=3.4u AS=5.1p AD=9.52p PS=6.4u PD=12.4u
M_d_258 VDD _n_287 _n_263 VDD PMOS_mst L=1u W=3.4u AS=9.52p AD=5.1p PS=12.4u PD=6.4u
M_d_259 _n_287 _n_263 VDD VDD PMOS_mst L=1u W=3.4u AS=5.1p AD=9.52p PS=6.4u PD=12.4u
M_d_260 VDD _n_308 _n_264 VDD PMOS_mst L=1u W=3.4u AS=9.52p AD=5.1p PS=12.4u PD=6.4u
M_d_261 _n_308 _n_264 VDD VDD PMOS_mst L=1u W=3.4u AS=5.1p AD=9.52p PS=6.4u PD=12.4u
M_d_262 VDD _n_288 _n_265 VDD PMOS_mst L=1u W=3.4u AS=9.52p AD=5.1p PS=12.4u PD=6.4u
M_d_263 _n_288 _n_265 VDD VDD PMOS_mst L=1u W=3.4u AS=5.1p AD=9.52p PS=6.4u PD=12.4u
M_d_264 VDD _n_289 _n_267 VDD PMOS_mst L=1u W=3.4u AS=9.52p AD=5.1p PS=12.4u PD=6.4u
M_d_265 _n_289 _n_267 VDD VDD PMOS_mst L=1u W=3.4u AS=5.1p AD=9.52p PS=6.4u PD=12.4u
M_d_266 VDD _n_310 _n_268 VDD PMOS_mst L=1u W=3.4u AS=9.52p AD=5.1p PS=12.4u PD=6.4u
M_d_267 _n_310 _n_268 VDD VDD PMOS_mst L=1u W=3.4u AS=5.1p AD=9.52p PS=6.4u PD=12.4u
M_d_268 VDD _n_290 _n_269 VDD PMOS_mst L=1u W=3.4u AS=9.52p AD=5.1p PS=12.4u PD=6.4u
M_d_269 _n_290 _n_269 VDD VDD PMOS_mst L=1u W=3.4u AS=5.1p AD=9.52p PS=6.4u PD=12.4u
M_d_270 VDD _n_311 _n_270 VDD PMOS_mst L=1u W=3.4u AS=9.52p AD=5.1p PS=12.4u PD=6.4u
M_d_271 _n_311 _n_270 VDD VDD PMOS_mst L=1u W=3.4u AS=5.1p AD=9.52p PS=6.4u PD=12.4u
M_d_272 VDD _n_291 _n_271 VDD PMOS_mst L=1u W=3.4u AS=9.52p AD=5.1p PS=12.4u PD=6.4u
M_d_273 _n_291 _n_271 VDD VDD PMOS_mst L=1u W=3.4u AS=5.1p AD=9.52p PS=6.4u PD=12.4u
M_d_274 VDD PRn BLn[0] VDD PMOS_mst L=1.6u W=3.4u AS=9.52p AD=5.1p PS=12.4u PD=6.4u
M_d_275 BLp[0] PRn VDD VDD PMOS_mst L=1.6u W=3.4u AS=5.1p AD=9.52p PS=6.4u PD=12.4u
M_d_276 VDD _n_296 _n_240 VDD PMOS_mst L=1u W=3.4u AS=9.52p AD=5.1p PS=12.4u PD=6.4u
M_d_277 _n_296 _n_240 VDD VDD PMOS_mst L=1u W=3.4u AS=5.1p AD=9.52p PS=6.4u PD=12.4u
M_d_278 VDD _n_276 _n_241 VDD PMOS_mst L=1u W=3.4u AS=9.52p AD=5.1p PS=12.4u PD=6.4u
M_d_279 _n_276 _n_241 VDD VDD PMOS_mst L=1u W=3.4u AS=5.1p AD=9.52p PS=6.4u PD=12.4u
M_d_280 VDD _n_282 _n_253 VDD PMOS_mst L=1u W=3.4u AS=9.52p AD=5.1p PS=12.4u PD=6.4u
M_d_281 _n_282 _n_253 VDD VDD PMOS_mst L=1u W=3.4u AS=5.1p AD=9.52p PS=6.4u PD=12.4u
M_d_282 VDD _n_303 _n_254 VDD PMOS_mst L=1u W=3.4u AS=9.52p AD=5.1p PS=12.4u PD=6.4u
M_d_283 _n_303 _n_254 VDD VDD PMOS_mst L=1u W=3.4u AS=5.1p AD=9.52p PS=6.4u PD=12.4u
M_d_284 VDD _n_283 _n_255 VDD PMOS_mst L=1u W=3.4u AS=9.52p AD=5.1p PS=12.4u PD=6.4u
M_d_285 _n_283 _n_255 VDD VDD PMOS_mst L=1u W=3.4u AS=5.1p AD=9.52p PS=6.4u PD=12.4u
M_d_286 VDD _n_309 _n_266 VDD PMOS_mst L=1u W=3.4u AS=9.52p AD=5.1p PS=12.4u PD=6.4u
M_d_287 _n_309 _n_266 VDD VDD PMOS_mst L=1u W=3.4u AS=5.1p AD=9.52p PS=6.4u PD=12.4u
M_d_288 _n_318 _n_355 VDD VDD PMOS_mst L=1u W=6.8u AS=14.62p AD=10.2p PS=18.8u PD=12.8u
M_d_290 _n_355 DIN[1] VDD VDD PMOS_mst L=1u W=6.8u AS=10.2p AD=14.62p PS=12.8u PD=18.8u
M_d_292 _n_352 LATp VDD VDD PMOS_mst L=1u W=6.8u AS=19.04p AD=14.53p PS=24.8u PD=18.449u
M_d_293 VDD _n_393 _n_352 VDD PMOS_mst L=1u W=3.4u AS=5.1p AD=5.1p PS=6.4u PD=6.4u
M_d_294 _n_393 _n_352 VDD VDD PMOS_mst L=1u W=3.4u AS=5.1p AD=5.1p PS=6.4u PD=6.4u
M_d_295 VDD LATp _n_393 VDD PMOS_mst L=1u W=6.8u AS=14.53p AD=19.04p PS=18.449u PD=24.8u
M_d_298 _n_353 _n_352 VDD VDD PMOS_mst L=1u W=10.8u AS=23.22p AD=16.2p PS=24.8u PD=16.8u
M_d_300 DO[1] _n_393 VDD VDD PMOS_mst L=1u W=10.8u AS=16.2p AD=23.22p PS=16.8u PD=24.8u
M_d_302 _n_372 WRn BLn[1] VDD PMOS_mst L=1u W=9.4u AS=26.32p AD=5.64p PS=24.4u PD=10.6u
M_d_303 VDD _n_318 _n_372 VDD PMOS_mst L=1u W=9.4u AS=5.64p AD=14.1p PS=10.6u PD=12.4u
M_d_304 _n_395 _n_355 VDD VDD PMOS_mst L=1u W=9.4u AS=14.1p AD=5.64p PS=12.4u PD=10.6u
M_d_305 BLp[1] WRn _n_395 VDD PMOS_mst L=1u W=9.4u AS=5.64p AD=26.32p PS=10.6u PD=24.4u
M_d_306 VDD _n_376 _n_320 VDD PMOS_mst L=1u W=3.4u AS=9.52p AD=5.1p PS=12.4u PD=6.4u
M_d_307 _n_376 _n_320 VDD VDD PMOS_mst L=1u W=3.4u AS=5.1p AD=9.52p PS=6.4u PD=12.4u
M_d_308 VDD _n_356 _n_321 VDD PMOS_mst L=1u W=3.4u AS=9.52p AD=5.1p PS=12.4u PD=6.4u
M_d_309 _n_356 _n_321 VDD VDD PMOS_mst L=1u W=3.4u AS=5.1p AD=9.52p PS=6.4u PD=12.4u
M_d_310 VDD _n_377 _n_322 VDD PMOS_mst L=1u W=3.4u AS=9.52p AD=5.1p PS=12.4u PD=6.4u
M_d_311 _n_377 _n_322 VDD VDD PMOS_mst L=1u W=3.4u AS=5.1p AD=9.52p PS=6.4u PD=12.4u
M_d_312 VDD _n_357 _n_323 VDD PMOS_mst L=1u W=3.4u AS=9.52p AD=5.1p PS=12.4u PD=6.4u
M_d_313 _n_357 _n_323 VDD VDD PMOS_mst L=1u W=3.4u AS=5.1p AD=9.52p PS=6.4u PD=12.4u
M_d_314 VDD _n_358 _n_325 VDD PMOS_mst L=1u W=3.4u AS=9.52p AD=5.1p PS=12.4u PD=6.4u
M_d_315 _n_358 _n_325 VDD VDD PMOS_mst L=1u W=3.4u AS=5.1p AD=9.52p PS=6.4u PD=12.4u
M_d_316 VDD _n_379 _n_326 VDD PMOS_mst L=1u W=3.4u AS=9.52p AD=5.1p PS=12.4u PD=6.4u
M_d_317 _n_379 _n_326 VDD VDD PMOS_mst L=1u W=3.4u AS=5.1p AD=9.52p PS=6.4u PD=12.4u
M_d_318 VDD _n_359 _n_327 VDD PMOS_mst L=1u W=3.4u AS=9.52p AD=5.1p PS=12.4u PD=6.4u
M_d_319 _n_359 _n_327 VDD VDD PMOS_mst L=1u W=3.4u AS=5.1p AD=9.52p PS=6.4u PD=12.4u
M_d_320 VDD _n_380 _n_328 VDD PMOS_mst L=1u W=3.4u AS=9.52p AD=5.1p PS=12.4u PD=6.4u
M_d_321 _n_380 _n_328 VDD VDD PMOS_mst L=1u W=3.4u AS=5.1p AD=9.52p PS=6.4u PD=12.4u
M_d_322 VDD _n_360 _n_329 VDD PMOS_mst L=1u W=3.4u AS=9.52p AD=5.1p PS=12.4u PD=6.4u
M_d_323 _n_360 _n_329 VDD VDD PMOS_mst L=1u W=3.4u AS=5.1p AD=9.52p PS=6.4u PD=12.4u
M_d_324 VDD _n_382 _n_332 VDD PMOS_mst L=1u W=3.4u AS=9.52p AD=5.1p PS=12.4u PD=6.4u
M_d_325 _n_382 _n_332 VDD VDD PMOS_mst L=1u W=3.4u AS=5.1p AD=9.52p PS=6.4u PD=12.4u
M_d_326 VDD _n_362 _n_333 VDD PMOS_mst L=1u W=3.4u AS=9.52p AD=5.1p PS=12.4u PD=6.4u
M_d_327 _n_362 _n_333 VDD VDD PMOS_mst L=1u W=3.4u AS=5.1p AD=9.52p PS=6.4u PD=12.4u
M_d_328 VDD _n_383 _n_334 VDD PMOS_mst L=1u W=3.4u AS=9.52p AD=5.1p PS=12.4u PD=6.4u
M_d_329 _n_383 _n_334 VDD VDD PMOS_mst L=1u W=3.4u AS=5.1p AD=9.52p PS=6.4u PD=12.4u
M_d_330 VDD _n_384 _n_336 VDD PMOS_mst L=1u W=3.4u AS=9.52p AD=5.1p PS=12.4u PD=6.4u
M_d_331 _n_384 _n_336 VDD VDD PMOS_mst L=1u W=3.4u AS=5.1p AD=9.52p PS=6.4u PD=12.4u
M_d_332 VDD _n_364 _n_337 VDD PMOS_mst L=1u W=3.4u AS=9.52p AD=5.1p PS=12.4u PD=6.4u
M_d_333 _n_364 _n_337 VDD VDD PMOS_mst L=1u W=3.4u AS=5.1p AD=9.52p PS=6.4u PD=12.4u
M_d_334 VDD _n_385 _n_338 VDD PMOS_mst L=1u W=3.4u AS=9.52p AD=5.1p PS=12.4u PD=6.4u
M_d_335 _n_385 _n_338 VDD VDD PMOS_mst L=1u W=3.4u AS=5.1p AD=9.52p PS=6.4u PD=12.4u
M_d_336 VDD _n_365 _n_339 VDD PMOS_mst L=1u W=3.4u AS=9.52p AD=5.1p PS=12.4u PD=6.4u
M_d_337 _n_365 _n_339 VDD VDD PMOS_mst L=1u W=3.4u AS=5.1p AD=9.52p PS=6.4u PD=12.4u
M_d_338 VDD _n_386 _n_340 VDD PMOS_mst L=1u W=3.4u AS=9.52p AD=5.1p PS=12.4u PD=6.4u
M_d_339 _n_386 _n_340 VDD VDD PMOS_mst L=1u W=3.4u AS=5.1p AD=9.52p PS=6.4u PD=12.4u
M_d_340 VDD _n_366 _n_341 VDD PMOS_mst L=1u W=3.4u AS=9.52p AD=5.1p PS=12.4u PD=6.4u
M_d_341 _n_366 _n_341 VDD VDD PMOS_mst L=1u W=3.4u AS=5.1p AD=9.52p PS=6.4u PD=12.4u
M_d_342 VDD _n_367 _n_343 VDD PMOS_mst L=1u W=3.4u AS=9.52p AD=5.1p PS=12.4u PD=6.4u
M_d_343 _n_367 _n_343 VDD VDD PMOS_mst L=1u W=3.4u AS=5.1p AD=9.52p PS=6.4u PD=12.4u
M_d_344 VDD _n_388 _n_344 VDD PMOS_mst L=1u W=3.4u AS=9.52p AD=5.1p PS=12.4u PD=6.4u
M_d_345 _n_388 _n_344 VDD VDD PMOS_mst L=1u W=3.4u AS=5.1p AD=9.52p PS=6.4u PD=12.4u
M_d_346 VDD _n_368 _n_345 VDD PMOS_mst L=1u W=3.4u AS=9.52p AD=5.1p PS=12.4u PD=6.4u
M_d_347 _n_368 _n_345 VDD VDD PMOS_mst L=1u W=3.4u AS=5.1p AD=9.52p PS=6.4u PD=12.4u
M_d_348 VDD _n_389 _n_346 VDD PMOS_mst L=1u W=3.4u AS=9.52p AD=5.1p PS=12.4u PD=6.4u
M_d_349 _n_389 _n_346 VDD VDD PMOS_mst L=1u W=3.4u AS=5.1p AD=9.52p PS=6.4u PD=12.4u
M_d_350 VDD _n_369 _n_347 VDD PMOS_mst L=1u W=3.4u AS=9.52p AD=5.1p PS=12.4u PD=6.4u
M_d_351 _n_369 _n_347 VDD VDD PMOS_mst L=1u W=3.4u AS=5.1p AD=9.52p PS=6.4u PD=12.4u
M_d_352 VDD _n_390 _n_348 VDD PMOS_mst L=1u W=3.4u AS=9.52p AD=5.1p PS=12.4u PD=6.4u
M_d_353 _n_390 _n_348 VDD VDD PMOS_mst L=1u W=3.4u AS=5.1p AD=9.52p PS=6.4u PD=12.4u
M_d_354 VDD _n_370 _n_349 VDD PMOS_mst L=1u W=3.4u AS=9.52p AD=5.1p PS=12.4u PD=6.4u
M_d_355 _n_370 _n_349 VDD VDD PMOS_mst L=1u W=3.4u AS=5.1p AD=9.52p PS=6.4u PD=12.4u
M_d_356 VDD _n_391 _n_350 VDD PMOS_mst L=1u W=3.4u AS=9.52p AD=5.1p PS=12.4u PD=6.4u
M_d_357 _n_391 _n_350 VDD VDD PMOS_mst L=1u W=3.4u AS=5.1p AD=9.52p PS=6.4u PD=12.4u
M_d_358 VDD _n_371 _n_351 VDD PMOS_mst L=1u W=3.4u AS=9.52p AD=5.1p PS=12.4u PD=6.4u
M_d_359 _n_371 _n_351 VDD VDD PMOS_mst L=1u W=3.4u AS=5.1p AD=9.52p PS=6.4u PD=12.4u
M_d_360 VDD _n_378 _n_324 VDD PMOS_mst L=1u W=3.4u AS=9.52p AD=5.1p PS=12.4u PD=6.4u
M_d_361 _n_378 _n_324 VDD VDD PMOS_mst L=1u W=3.4u AS=5.1p AD=9.52p PS=6.4u PD=12.4u
M_d_362 VDD _n_381 _n_330 VDD PMOS_mst L=1u W=3.4u AS=9.52p AD=5.1p PS=12.4u PD=6.4u
M_d_363 _n_381 _n_330 VDD VDD PMOS_mst L=1u W=3.4u AS=5.1p AD=9.52p PS=6.4u PD=12.4u
M_d_364 VDD _n_361 _n_331 VDD PMOS_mst L=1u W=3.4u AS=9.52p AD=5.1p PS=12.4u PD=6.4u
M_d_365 _n_361 _n_331 VDD VDD PMOS_mst L=1u W=3.4u AS=5.1p AD=9.52p PS=6.4u PD=12.4u
M_d_366 VDD _n_363 _n_335 VDD PMOS_mst L=1u W=3.4u AS=9.52p AD=5.1p PS=12.4u PD=6.4u
M_d_367 _n_363 _n_335 VDD VDD PMOS_mst L=1u W=3.4u AS=5.1p AD=9.52p PS=6.4u PD=12.4u
M_d_368 VDD _n_387 _n_342 VDD PMOS_mst L=1u W=3.4u AS=9.52p AD=5.1p PS=12.4u PD=6.4u
M_d_369 _n_387 _n_342 VDD VDD PMOS_mst L=1u W=3.4u AS=5.1p AD=9.52p PS=6.4u PD=12.4u
M_d_370 VDD PRn BLn[1] VDD PMOS_mst L=1.6u W=3.4u AS=9.52p AD=5.1p PS=12.4u PD=6.4u
M_d_371 BLp[1] PRn VDD VDD PMOS_mst L=1.6u W=3.4u AS=5.1p AD=9.52p PS=6.4u PD=12.4u
M_d_372 _n_398 _n_435 VDD VDD PMOS_mst L=1u W=6.8u AS=14.62p AD=10.2p PS=18.8u PD=12.8u
M_d_374 _n_435 DIN[2] VDD VDD PMOS_mst L=1u W=6.8u AS=10.2p AD=14.62p PS=12.8u PD=18.8u
M_d_376 _n_432 LATp VDD VDD PMOS_mst L=1u W=6.8u AS=19.04p AD=14.53p PS=24.8u PD=18.449u
M_d_377 VDD _n_473 _n_432 VDD PMOS_mst L=1u W=3.4u AS=5.1p AD=5.1p PS=6.4u PD=6.4u
M_d_378 _n_473 _n_432 VDD VDD PMOS_mst L=1u W=3.4u AS=5.1p AD=5.1p PS=6.4u PD=6.4u
M_d_379 VDD LATp _n_473 VDD PMOS_mst L=1u W=6.8u AS=14.53p AD=19.04p PS=18.449u PD=24.8u
M_d_382 _n_433 _n_432 VDD VDD PMOS_mst L=1u W=10.8u AS=23.22p AD=16.2p PS=24.8u PD=16.8u
M_d_384 DO[2] _n_473 VDD VDD PMOS_mst L=1u W=10.8u AS=16.2p AD=23.22p PS=16.8u PD=24.8u
M_d_386 _n_452 WRn BLn[2] VDD PMOS_mst L=1u W=9.4u AS=26.32p AD=5.64p PS=24.4u PD=10.6u
M_d_387 VDD _n_398 _n_452 VDD PMOS_mst L=1u W=9.4u AS=5.64p AD=14.1p PS=10.6u PD=12.4u
M_d_388 _n_475 _n_435 VDD VDD PMOS_mst L=1u W=9.4u AS=14.1p AD=5.64p PS=12.4u PD=10.6u
M_d_389 BLp[2] WRn _n_475 VDD PMOS_mst L=1u W=9.4u AS=5.64p AD=26.32p PS=10.6u PD=24.4u
M_d_390 VDD _n_456 _n_400 VDD PMOS_mst L=1u W=3.4u AS=9.52p AD=5.1p PS=12.4u PD=6.4u
M_d_391 _n_456 _n_400 VDD VDD PMOS_mst L=1u W=3.4u AS=5.1p AD=9.52p PS=6.4u PD=12.4u
M_d_392 VDD _n_436 _n_401 VDD PMOS_mst L=1u W=3.4u AS=9.52p AD=5.1p PS=12.4u PD=6.4u
M_d_393 _n_436 _n_401 VDD VDD PMOS_mst L=1u W=3.4u AS=5.1p AD=9.52p PS=6.4u PD=12.4u
M_d_394 VDD _n_458 _n_404 VDD PMOS_mst L=1u W=3.4u AS=9.52p AD=5.1p PS=12.4u PD=6.4u
M_d_395 _n_458 _n_404 VDD VDD PMOS_mst L=1u W=3.4u AS=5.1p AD=9.52p PS=6.4u PD=12.4u
M_d_396 VDD _n_438 _n_405 VDD PMOS_mst L=1u W=3.4u AS=9.52p AD=5.1p PS=12.4u PD=6.4u
M_d_397 _n_438 _n_405 VDD VDD PMOS_mst L=1u W=3.4u AS=5.1p AD=9.52p PS=6.4u PD=12.4u
M_d_398 VDD _n_459 _n_406 VDD PMOS_mst L=1u W=3.4u AS=9.52p AD=5.1p PS=12.4u PD=6.4u
M_d_399 _n_459 _n_406 VDD VDD PMOS_mst L=1u W=3.4u AS=5.1p AD=9.52p PS=6.4u PD=12.4u
M_d_400 VDD _n_440 _n_409 VDD PMOS_mst L=1u W=3.4u AS=9.52p AD=5.1p PS=12.4u PD=6.4u
M_d_401 _n_440 _n_409 VDD VDD PMOS_mst L=1u W=3.4u AS=5.1p AD=9.52p PS=6.4u PD=12.4u
M_d_402 VDD _n_461 _n_410 VDD PMOS_mst L=1u W=3.4u AS=9.52p AD=5.1p PS=12.4u PD=6.4u
M_d_403 _n_461 _n_410 VDD VDD PMOS_mst L=1u W=3.4u AS=5.1p AD=9.52p PS=6.4u PD=12.4u
M_d_404 VDD _n_441 _n_411 VDD PMOS_mst L=1u W=3.4u AS=9.52p AD=5.1p PS=12.4u PD=6.4u
M_d_405 _n_441 _n_411 VDD VDD PMOS_mst L=1u W=3.4u AS=5.1p AD=9.52p PS=6.4u PD=12.4u
M_d_406 VDD _n_462 _n_412 VDD PMOS_mst L=1u W=3.4u AS=9.52p AD=5.1p PS=12.4u PD=6.4u
M_d_407 _n_462 _n_412 VDD VDD PMOS_mst L=1u W=3.4u AS=5.1p AD=9.52p PS=6.4u PD=12.4u
M_d_408 VDD _n_463 _n_414 VDD PMOS_mst L=1u W=3.4u AS=9.52p AD=5.1p PS=12.4u PD=6.4u
M_d_409 _n_463 _n_414 VDD VDD PMOS_mst L=1u W=3.4u AS=5.1p AD=9.52p PS=6.4u PD=12.4u
M_d_410 VDD _n_444 _n_417 VDD PMOS_mst L=1u W=3.4u AS=9.52p AD=5.1p PS=12.4u PD=6.4u
M_d_411 _n_444 _n_417 VDD VDD PMOS_mst L=1u W=3.4u AS=5.1p AD=9.52p PS=6.4u PD=12.4u
M_d_412 VDD _n_465 _n_418 VDD PMOS_mst L=1u W=3.4u AS=9.52p AD=5.1p PS=12.4u PD=6.4u
M_d_413 _n_465 _n_418 VDD VDD PMOS_mst L=1u W=3.4u AS=5.1p AD=9.52p PS=6.4u PD=12.4u
M_d_414 VDD _n_445 _n_419 VDD PMOS_mst L=1u W=3.4u AS=9.52p AD=5.1p PS=12.4u PD=6.4u
M_d_415 _n_445 _n_419 VDD VDD PMOS_mst L=1u W=3.4u AS=5.1p AD=9.52p PS=6.4u PD=12.4u
M_d_416 VDD _n_466 _n_420 VDD PMOS_mst L=1u W=3.4u AS=9.52p AD=5.1p PS=12.4u PD=6.4u
M_d_417 _n_466 _n_420 VDD VDD PMOS_mst L=1u W=3.4u AS=5.1p AD=9.52p PS=6.4u PD=12.4u
M_d_418 VDD _n_446 _n_421 VDD PMOS_mst L=1u W=3.4u AS=9.52p AD=5.1p PS=12.4u PD=6.4u
M_d_419 _n_446 _n_421 VDD VDD PMOS_mst L=1u W=3.4u AS=5.1p AD=9.52p PS=6.4u PD=12.4u
M_d_420 VDD _n_467 _n_422 VDD PMOS_mst L=1u W=3.4u AS=9.52p AD=5.1p PS=12.4u PD=6.4u
M_d_421 _n_467 _n_422 VDD VDD PMOS_mst L=1u W=3.4u AS=5.1p AD=9.52p PS=6.4u PD=12.4u
M_d_422 VDD _n_447 _n_423 VDD PMOS_mst L=1u W=3.4u AS=9.52p AD=5.1p PS=12.4u PD=6.4u
M_d_423 _n_447 _n_423 VDD VDD PMOS_mst L=1u W=3.4u AS=5.1p AD=9.52p PS=6.4u PD=12.4u
M_d_424 VDD _n_448 _n_425 VDD PMOS_mst L=1u W=3.4u AS=9.52p AD=5.1p PS=12.4u PD=6.4u
M_d_425 _n_448 _n_425 VDD VDD PMOS_mst L=1u W=3.4u AS=5.1p AD=9.52p PS=6.4u PD=12.4u
M_d_426 VDD _n_469 _n_426 VDD PMOS_mst L=1u W=3.4u AS=9.52p AD=5.1p PS=12.4u PD=6.4u
M_d_427 _n_469 _n_426 VDD VDD PMOS_mst L=1u W=3.4u AS=5.1p AD=9.52p PS=6.4u PD=12.4u
M_d_428 VDD _n_449 _n_427 VDD PMOS_mst L=1u W=3.4u AS=9.52p AD=5.1p PS=12.4u PD=6.4u
M_d_429 _n_449 _n_427 VDD VDD PMOS_mst L=1u W=3.4u AS=5.1p AD=9.52p PS=6.4u PD=12.4u
M_d_430 VDD _n_470 _n_428 VDD PMOS_mst L=1u W=3.4u AS=9.52p AD=5.1p PS=12.4u PD=6.4u
M_d_431 _n_470 _n_428 VDD VDD PMOS_mst L=1u W=3.4u AS=5.1p AD=9.52p PS=6.4u PD=12.4u
M_d_432 VDD _n_471 _n_430 VDD PMOS_mst L=1u W=3.4u AS=9.52p AD=5.1p PS=12.4u PD=6.4u
M_d_433 _n_471 _n_430 VDD VDD PMOS_mst L=1u W=3.4u AS=5.1p AD=9.52p PS=6.4u PD=12.4u
M_d_434 VDD _n_451 _n_431 VDD PMOS_mst L=1u W=3.4u AS=9.52p AD=5.1p PS=12.4u PD=6.4u
M_d_435 _n_451 _n_431 VDD VDD PMOS_mst L=1u W=3.4u AS=5.1p AD=9.52p PS=6.4u PD=12.4u
M_d_436 VDD PRn BLn[2] VDD PMOS_mst L=1.6u W=3.4u AS=9.52p AD=5.1p PS=12.4u PD=6.4u
M_d_437 BLp[2] PRn VDD VDD PMOS_mst L=1.6u W=3.4u AS=5.1p AD=9.52p PS=6.4u PD=12.4u
M_d_438 VDD _n_457 _n_402 VDD PMOS_mst L=1u W=3.4u AS=9.52p AD=5.1p PS=12.4u PD=6.4u
M_d_439 _n_457 _n_402 VDD VDD PMOS_mst L=1u W=3.4u AS=5.1p AD=9.52p PS=6.4u PD=12.4u
M_d_440 VDD _n_437 _n_403 VDD PMOS_mst L=1u W=3.4u AS=9.52p AD=5.1p PS=12.4u PD=6.4u
M_d_441 _n_437 _n_403 VDD VDD PMOS_mst L=1u W=3.4u AS=5.1p AD=9.52p PS=6.4u PD=12.4u
M_d_442 VDD _n_439 _n_407 VDD PMOS_mst L=1u W=3.4u AS=9.52p AD=5.1p PS=12.4u PD=6.4u
M_d_443 _n_439 _n_407 VDD VDD PMOS_mst L=1u W=3.4u AS=5.1p AD=9.52p PS=6.4u PD=12.4u
M_d_444 VDD _n_460 _n_408 VDD PMOS_mst L=1u W=3.4u AS=9.52p AD=5.1p PS=12.4u PD=6.4u
M_d_445 _n_460 _n_408 VDD VDD PMOS_mst L=1u W=3.4u AS=5.1p AD=9.52p PS=6.4u PD=12.4u
M_d_446 VDD _n_442 _n_413 VDD PMOS_mst L=1u W=3.4u AS=9.52p AD=5.1p PS=12.4u PD=6.4u
M_d_447 _n_442 _n_413 VDD VDD PMOS_mst L=1u W=3.4u AS=5.1p AD=9.52p PS=6.4u PD=12.4u
M_d_448 VDD _n_443 _n_415 VDD PMOS_mst L=1u W=3.4u AS=9.52p AD=5.1p PS=12.4u PD=6.4u
M_d_449 _n_443 _n_415 VDD VDD PMOS_mst L=1u W=3.4u AS=5.1p AD=9.52p PS=6.4u PD=12.4u
M_d_450 VDD _n_464 _n_416 VDD PMOS_mst L=1u W=3.4u AS=9.52p AD=5.1p PS=12.4u PD=6.4u
M_d_451 _n_464 _n_416 VDD VDD PMOS_mst L=1u W=3.4u AS=5.1p AD=9.52p PS=6.4u PD=12.4u
M_d_452 VDD _n_468 _n_424 VDD PMOS_mst L=1u W=3.4u AS=9.52p AD=5.1p PS=12.4u PD=6.4u
M_d_453 _n_468 _n_424 VDD VDD PMOS_mst L=1u W=3.4u AS=5.1p AD=9.52p PS=6.4u PD=12.4u
M_d_454 VDD _n_450 _n_429 VDD PMOS_mst L=1u W=3.4u AS=9.52p AD=5.1p PS=12.4u PD=6.4u
M_d_455 _n_450 _n_429 VDD VDD PMOS_mst L=1u W=3.4u AS=5.1p AD=9.52p PS=6.4u PD=12.4u
M_d_456 _n_478 _n_515 VDD VDD PMOS_mst L=1u W=6.8u AS=14.62p AD=10.2p PS=18.8u PD=12.8u
M_d_458 _n_515 DIN[3] VDD VDD PMOS_mst L=1u W=6.8u AS=10.2p AD=14.62p PS=12.8u PD=18.8u
M_d_460 _n_512 LATp VDD VDD PMOS_mst L=1u W=6.8u AS=19.04p AD=14.53p PS=24.8u PD=18.449u
M_d_461 VDD _n_553 _n_512 VDD PMOS_mst L=1u W=3.4u AS=5.1p AD=5.1p PS=6.4u PD=6.4u
M_d_462 _n_553 _n_512 VDD VDD PMOS_mst L=1u W=3.4u AS=5.1p AD=5.1p PS=6.4u PD=6.4u
M_d_463 VDD LATp _n_553 VDD PMOS_mst L=1u W=6.8u AS=14.53p AD=19.04p PS=18.449u PD=24.8u
M_d_466 _n_513 _n_512 VDD VDD PMOS_mst L=1u W=10.8u AS=23.22p AD=16.2p PS=24.8u PD=16.8u
M_d_468 DO[3] _n_553 VDD VDD PMOS_mst L=1u W=10.8u AS=16.2p AD=23.22p PS=16.8u PD=24.8u
M_d_470 _n_532 WRn BLn[3] VDD PMOS_mst L=1u W=9.4u AS=26.32p AD=5.64p PS=24.4u PD=10.6u
M_d_471 VDD _n_478 _n_532 VDD PMOS_mst L=1u W=9.4u AS=5.64p AD=14.1p PS=10.6u PD=12.4u
M_d_472 _n_555 _n_515 VDD VDD PMOS_mst L=1u W=9.4u AS=14.1p AD=5.64p PS=12.4u PD=10.6u
M_d_473 BLp[3] WRn _n_555 VDD PMOS_mst L=1u W=9.4u AS=5.64p AD=26.32p PS=10.6u PD=24.4u
M_d_474 VDD _n_536 _n_480 VDD PMOS_mst L=1u W=3.4u AS=9.52p AD=5.1p PS=12.4u PD=6.4u
M_d_475 _n_536 _n_480 VDD VDD PMOS_mst L=1u W=3.4u AS=5.1p AD=9.52p PS=6.4u PD=12.4u
M_d_476 VDD _n_516 _n_481 VDD PMOS_mst L=1u W=3.4u AS=9.52p AD=5.1p PS=12.4u PD=6.4u
M_d_477 _n_516 _n_481 VDD VDD PMOS_mst L=1u W=3.4u AS=5.1p AD=9.52p PS=6.4u PD=12.4u
M_d_478 VDD _n_537 _n_482 VDD PMOS_mst L=1u W=3.4u AS=9.52p AD=5.1p PS=12.4u PD=6.4u
M_d_479 _n_537 _n_482 VDD VDD PMOS_mst L=1u W=3.4u AS=5.1p AD=9.52p PS=6.4u PD=12.4u
M_d_480 VDD _n_517 _n_483 VDD PMOS_mst L=1u W=3.4u AS=9.52p AD=5.1p PS=12.4u PD=6.4u
M_d_481 _n_517 _n_483 VDD VDD PMOS_mst L=1u W=3.4u AS=5.1p AD=9.52p PS=6.4u PD=12.4u
M_d_482 VDD _n_538 _n_484 VDD PMOS_mst L=1u W=3.4u AS=9.52p AD=5.1p PS=12.4u PD=6.4u
M_d_483 _n_538 _n_484 VDD VDD PMOS_mst L=1u W=3.4u AS=5.1p AD=9.52p PS=6.4u PD=12.4u
M_d_484 VDD _n_518 _n_485 VDD PMOS_mst L=1u W=3.4u AS=9.52p AD=5.1p PS=12.4u PD=6.4u
M_d_485 _n_518 _n_485 VDD VDD PMOS_mst L=1u W=3.4u AS=5.1p AD=9.52p PS=6.4u PD=12.4u
M_d_486 VDD _n_539 _n_486 VDD PMOS_mst L=1u W=3.4u AS=9.52p AD=5.1p PS=12.4u PD=6.4u
M_d_487 _n_539 _n_486 VDD VDD PMOS_mst L=1u W=3.4u AS=5.1p AD=9.52p PS=6.4u PD=12.4u
M_d_488 VDD _n_519 _n_487 VDD PMOS_mst L=1u W=3.4u AS=9.52p AD=5.1p PS=12.4u PD=6.4u
M_d_489 _n_519 _n_487 VDD VDD PMOS_mst L=1u W=3.4u AS=5.1p AD=9.52p PS=6.4u PD=12.4u
M_d_490 VDD _n_541 _n_490 VDD PMOS_mst L=1u W=3.4u AS=9.52p AD=5.1p PS=12.4u PD=6.4u
M_d_491 _n_541 _n_490 VDD VDD PMOS_mst L=1u W=3.4u AS=5.1p AD=9.52p PS=6.4u PD=12.4u
M_d_492 VDD _n_521 _n_491 VDD PMOS_mst L=1u W=3.4u AS=9.52p AD=5.1p PS=12.4u PD=6.4u
M_d_493 _n_521 _n_491 VDD VDD PMOS_mst L=1u W=3.4u AS=5.1p AD=9.52p PS=6.4u PD=12.4u
M_d_494 VDD _n_542 _n_492 VDD PMOS_mst L=1u W=3.4u AS=9.52p AD=5.1p PS=12.4u PD=6.4u
M_d_495 _n_542 _n_492 VDD VDD PMOS_mst L=1u W=3.4u AS=5.1p AD=9.52p PS=6.4u PD=12.4u
M_d_496 VDD _n_522 _n_493 VDD PMOS_mst L=1u W=3.4u AS=9.52p AD=5.1p PS=12.4u PD=6.4u
M_d_497 _n_522 _n_493 VDD VDD PMOS_mst L=1u W=3.4u AS=5.1p AD=9.52p PS=6.4u PD=12.4u
M_d_498 VDD _n_543 _n_494 VDD PMOS_mst L=1u W=3.4u AS=9.52p AD=5.1p PS=12.4u PD=6.4u
M_d_499 _n_543 _n_494 VDD VDD PMOS_mst L=1u W=3.4u AS=5.1p AD=9.52p PS=6.4u PD=12.4u
M_d_500 VDD _n_523 _n_495 VDD PMOS_mst L=1u W=3.4u AS=9.52p AD=5.1p PS=12.4u PD=6.4u
M_d_501 _n_523 _n_495 VDD VDD PMOS_mst L=1u W=3.4u AS=5.1p AD=9.52p PS=6.4u PD=12.4u
M_d_502 VDD _n_544 _n_496 VDD PMOS_mst L=1u W=3.4u AS=9.52p AD=5.1p PS=12.4u PD=6.4u
M_d_503 _n_544 _n_496 VDD VDD PMOS_mst L=1u W=3.4u AS=5.1p AD=9.52p PS=6.4u PD=12.4u
M_d_504 VDD _n_524 _n_497 VDD PMOS_mst L=1u W=3.4u AS=9.52p AD=5.1p PS=12.4u PD=6.4u
M_d_505 _n_524 _n_497 VDD VDD PMOS_mst L=1u W=3.4u AS=5.1p AD=9.52p PS=6.4u PD=12.4u
M_d_506 VDD _n_545 _n_498 VDD PMOS_mst L=1u W=3.4u AS=9.52p AD=5.1p PS=12.4u PD=6.4u
M_d_507 _n_545 _n_498 VDD VDD PMOS_mst L=1u W=3.4u AS=5.1p AD=9.52p PS=6.4u PD=12.4u
M_d_508 VDD _n_525 _n_499 VDD PMOS_mst L=1u W=3.4u AS=9.52p AD=5.1p PS=12.4u PD=6.4u
M_d_509 _n_525 _n_499 VDD VDD PMOS_mst L=1u W=3.4u AS=5.1p AD=9.52p PS=6.4u PD=12.4u
M_d_510 VDD _n_546 _n_500 VDD PMOS_mst L=1u W=3.4u AS=9.52p AD=5.1p PS=12.4u PD=6.4u
M_d_511 _n_546 _n_500 VDD VDD PMOS_mst L=1u W=3.4u AS=5.1p AD=9.52p PS=6.4u PD=12.4u
M_d_512 VDD _n_526 _n_501 VDD PMOS_mst L=1u W=3.4u AS=9.52p AD=5.1p PS=12.4u PD=6.4u
M_d_513 _n_526 _n_501 VDD VDD PMOS_mst L=1u W=3.4u AS=5.1p AD=9.52p PS=6.4u PD=12.4u
M_d_514 VDD _n_547 _n_502 VDD PMOS_mst L=1u W=3.4u AS=9.52p AD=5.1p PS=12.4u PD=6.4u
M_d_515 _n_547 _n_502 VDD VDD PMOS_mst L=1u W=3.4u AS=5.1p AD=9.52p PS=6.4u PD=12.4u
M_d_516 VDD _n_527 _n_503 VDD PMOS_mst L=1u W=3.4u AS=9.52p AD=5.1p PS=12.4u PD=6.4u
M_d_517 _n_527 _n_503 VDD VDD PMOS_mst L=1u W=3.4u AS=5.1p AD=9.52p PS=6.4u PD=12.4u
M_d_518 VDD _n_528 _n_505 VDD PMOS_mst L=1u W=3.4u AS=9.52p AD=5.1p PS=12.4u PD=6.4u
M_d_519 _n_528 _n_505 VDD VDD PMOS_mst L=1u W=3.4u AS=5.1p AD=9.52p PS=6.4u PD=12.4u
M_d_520 VDD _n_549 _n_506 VDD PMOS_mst L=1u W=3.4u AS=9.52p AD=5.1p PS=12.4u PD=6.4u
M_d_521 _n_549 _n_506 VDD VDD PMOS_mst L=1u W=3.4u AS=5.1p AD=9.52p PS=6.4u PD=12.4u
M_d_522 VDD _n_529 _n_507 VDD PMOS_mst L=1u W=3.4u AS=9.52p AD=5.1p PS=12.4u PD=6.4u
M_d_523 _n_529 _n_507 VDD VDD PMOS_mst L=1u W=3.4u AS=5.1p AD=9.52p PS=6.4u PD=12.4u
M_d_524 VDD _n_550 _n_508 VDD PMOS_mst L=1u W=3.4u AS=9.52p AD=5.1p PS=12.4u PD=6.4u
M_d_525 _n_550 _n_508 VDD VDD PMOS_mst L=1u W=3.4u AS=5.1p AD=9.52p PS=6.4u PD=12.4u
M_d_526 VDD _n_530 _n_509 VDD PMOS_mst L=1u W=3.4u AS=9.52p AD=5.1p PS=12.4u PD=6.4u
M_d_527 _n_530 _n_509 VDD VDD PMOS_mst L=1u W=3.4u AS=5.1p AD=9.52p PS=6.4u PD=12.4u
M_d_528 VDD _n_551 _n_510 VDD PMOS_mst L=1u W=3.4u AS=9.52p AD=5.1p PS=12.4u PD=6.4u
M_d_529 _n_551 _n_510 VDD VDD PMOS_mst L=1u W=3.4u AS=5.1p AD=9.52p PS=6.4u PD=12.4u
M_d_530 VDD PRn BLn[3] VDD PMOS_mst L=1.6u W=3.4u AS=9.52p AD=5.1p PS=12.4u PD=6.4u
M_d_531 BLp[3] PRn VDD VDD PMOS_mst L=1.6u W=3.4u AS=5.1p AD=9.52p PS=6.4u PD=12.4u
M_d_532 VDD _n_540 _n_488 VDD PMOS_mst L=1u W=3.4u AS=9.52p AD=5.1p PS=12.4u PD=6.4u
M_d_533 _n_540 _n_488 VDD VDD PMOS_mst L=1u W=3.4u AS=5.1p AD=9.52p PS=6.4u PD=12.4u
M_d_534 VDD _n_520 _n_489 VDD PMOS_mst L=1u W=3.4u AS=9.52p AD=5.1p PS=12.4u PD=6.4u
M_d_535 _n_520 _n_489 VDD VDD PMOS_mst L=1u W=3.4u AS=5.1p AD=9.52p PS=6.4u PD=12.4u
M_d_536 VDD _n_548 _n_504 VDD PMOS_mst L=1u W=3.4u AS=9.52p AD=5.1p PS=12.4u PD=6.4u
M_d_537 _n_548 _n_504 VDD VDD PMOS_mst L=1u W=3.4u AS=5.1p AD=9.52p PS=6.4u PD=12.4u
M_d_538 VDD _n_531 _n_511 VDD PMOS_mst L=1u W=3.4u AS=9.52p AD=5.1p PS=12.4u PD=6.4u
M_d_539 _n_531 _n_511 VDD VDD PMOS_mst L=1u W=3.4u AS=5.1p AD=9.52p PS=6.4u PD=12.4u
M_d_541 VSS A0 A0n VSS NMOS_mst L=1u W=3.4u AS=9.52p AD=5.1p PS=12.4u PD=6.4u
M_d_542 A0p A0n VSS VSS NMOS_mst L=1u W=3.4u AS=5.1p AD=9.52p PS=6.4u PD=12.4u
M_d_543 VSS _n_11 _n_8 VSS NMOS_mst L=1u W=3.4u AS=9.52p AD=5.1p PS=12.4u PD=6.4u
M_d_544 _n_11 A4 VSS VSS NMOS_mst L=1u W=3.4u AS=5.1p AD=9.52p PS=6.4u PD=12.4u
M_d_545 VSS _n_10 PR0 VSS NMOS_mst L=1u W=3.4u AS=9.52p AD=9.52p PS=12.4u PD=12.4u
M_d_546 _n_16 _n_11 _n_10 VSS NMOS_mst L=1u W=3.4u AS=9.52p AD=2.04p PS=12.4u PD=4.6u
M_d_547 VSS _n_15 _n_16 VSS NMOS_mst L=1u W=3.4u AS=2.04p AD=5.1p PS=4.6u PD=6.4u
M_d_548 _n_21 _n_15 VSS VSS NMOS_mst L=1u W=3.4u AS=5.1p AD=2.04p PS=6.4u PD=4.6u
M_d_549 _n_19 _n_8 _n_21 VSS NMOS_mst L=1u W=3.4u AS=2.04p AD=9.52p PS=4.6u PD=12.4u
M_d_550 VSS A1 A1n VSS NMOS_mst L=1u W=3.4u AS=9.52p AD=5.1p PS=12.4u PD=6.4u
M_d_551 A1p A1n VSS VSS NMOS_mst L=1u W=3.4u AS=5.1p AD=9.52p PS=6.4u PD=12.4u
M_d_552 PR1 _n_19 VSS VSS NMOS_mst L=1u W=3.4u AS=9.52p AD=9.52p PS=12.4u PD=12.4u
M_d_553 VSS _n_20 _n_15 VSS NMOS_mst L=1u W=3.4u AS=9.52p AD=5.1p PS=12.4u PD=6.4u
M_d_554 _n_20 CE VSS VSS NMOS_mst L=1u W=3.4u AS=5.1p AD=9.52p PS=6.4u PD=12.4u
M_d_555 VSS A2 A2n VSS NMOS_mst L=1u W=3.4u AS=9.52p AD=5.1p PS=12.4u PD=6.4u
M_d_556 A2p A2n VSS VSS NMOS_mst L=1u W=3.4u AS=5.1p AD=9.52p PS=6.4u PD=12.4u
M_d_557 VSS _n_46 CE_CEp VSS NMOS_mst L=1u W=3.4u AS=9.52p AD=5.1p PS=12.4u PD=6.4u
M_d_558 _n_47 _n_46 VSS VSS NMOS_mst L=10u W=3.4u AS=5.1p AD=9.52p PS=6.4u PD=12.4u
M_d_559 VSS CE _n_46 VSS NMOS_mst L=1u W=3.4u AS=9.52p AD=8.5p PS=12.4u PD=8.4u
M_d_560 _n_64 _n_47 VSS VSS NMOS_mst L=2u W=3.4u AS=8.5p AD=9.52p PS=8.4u PD=12.4u
M_d_561 VSS A3 A3n VSS NMOS_mst L=1u W=3.4u AS=9.52p AD=5.1p PS=12.4u PD=6.4u
M_d_562 A3p A3n VSS VSS NMOS_mst L=1u W=3.4u AS=5.1p AD=9.52p PS=6.4u PD=12.4u
M_d_563 _n_65 A3n _n_29 VSS NMOS_mst L=1u W=3.4u AS=9.52p AD=2.04p PS=12.4u PD=4.6u
M_d_564 _n_66 A2n _n_65 VSS NMOS_mst L=1u W=3.4u AS=2.04p AD=2.04p PS=4.6u PD=4.6u
M_d_565 _n_67 A1n _n_66 VSS NMOS_mst L=1u W=3.4u AS=2.04p AD=2.04p PS=4.6u PD=4.6u
M_d_566 _n_164 A0n _n_67 VSS NMOS_mst L=1u W=3.4u AS=2.04p AD=2.04p PS=4.6u PD=4.6u
M_d_567 VSS PR0 _n_164 VSS NMOS_mst L=1u W=3.4u AS=2.04p AD=5.1p PS=4.6u PD=6.4u
M_d_568 _n_197 _n_29 VSS VSS NMOS_mst L=1u W=13.6u AS=20.4p AD=24.82p PS=25.6u PD=31.6u
M_d_572 _n_70 A3n _n_48 VSS NMOS_mst L=1u W=3.4u AS=9.52p AD=2.04p PS=12.4u PD=4.6u
M_d_573 _n_71 A2n _n_70 VSS NMOS_mst L=1u W=3.4u AS=2.04p AD=2.04p PS=4.6u PD=4.6u
M_d_574 _n_69 A1n _n_71 VSS NMOS_mst L=1u W=3.4u AS=2.04p AD=2.04p PS=4.6u PD=4.6u
M_d_575 _n_167 A0p _n_69 VSS NMOS_mst L=1u W=3.4u AS=2.04p AD=2.04p PS=4.6u PD=4.6u
M_d_576 VSS PR0 _n_167 VSS NMOS_mst L=1u W=3.4u AS=2.04p AD=5.1p PS=4.6u PD=6.4u
M_d_577 _n_198 _n_48 VSS VSS NMOS_mst L=1u W=13.6u AS=20.4p AD=24.82p PS=25.6u PD=31.6u
M_d_581 _n_72 A3n _n_30 VSS NMOS_mst L=1u W=3.4u AS=9.52p AD=2.04p PS=12.4u PD=4.6u
M_d_582 _n_73 A2n _n_72 VSS NMOS_mst L=1u W=3.4u AS=2.04p AD=2.04p PS=4.6u PD=4.6u
M_d_583 _n_74 A1p _n_73 VSS NMOS_mst L=1u W=3.4u AS=2.04p AD=2.04p PS=4.6u PD=4.6u
M_d_584 _n_168 A0n _n_74 VSS NMOS_mst L=1u W=3.4u AS=2.04p AD=2.04p PS=4.6u PD=4.6u
M_d_585 VSS PR0 _n_168 VSS NMOS_mst L=1u W=3.4u AS=2.04p AD=5.1p PS=4.6u PD=6.4u
M_d_586 _n_199 _n_30 VSS VSS NMOS_mst L=1u W=13.6u AS=20.4p AD=24.82p PS=25.6u PD=31.6u
M_d_590 _n_81 A3n _n_49 VSS NMOS_mst L=1u W=3.4u AS=9.52p AD=2.04p PS=12.4u PD=4.6u
M_d_591 _n_79 A2n _n_81 VSS NMOS_mst L=1u W=3.4u AS=2.04p AD=2.04p PS=4.6u PD=4.6u
M_d_592 _n_80 A1p _n_79 VSS NMOS_mst L=1u W=3.4u AS=2.04p AD=2.04p PS=4.6u PD=4.6u
M_d_593 _n_171 A0p _n_80 VSS NMOS_mst L=1u W=3.4u AS=2.04p AD=2.04p PS=4.6u PD=4.6u
M_d_594 VSS PR0 _n_171 VSS NMOS_mst L=1u W=3.4u AS=2.04p AD=5.1p PS=4.6u PD=6.4u
M_d_595 _n_200 _n_49 VSS VSS NMOS_mst L=1u W=13.6u AS=20.4p AD=24.82p PS=25.6u PD=31.6u
M_d_599 _n_85 A3n _n_31 VSS NMOS_mst L=1u W=3.4u AS=9.52p AD=2.04p PS=12.4u PD=4.6u
M_d_600 _n_86 A2p _n_85 VSS NMOS_mst L=1u W=3.4u AS=2.04p AD=2.04p PS=4.6u PD=4.6u
M_d_601 _n_84 A1n _n_86 VSS NMOS_mst L=1u W=3.4u AS=2.04p AD=2.04p PS=4.6u PD=4.6u
M_d_602 _n_173 A0n _n_84 VSS NMOS_mst L=1u W=3.4u AS=2.04p AD=2.04p PS=4.6u PD=4.6u
M_d_603 VSS PR0 _n_173 VSS NMOS_mst L=1u W=3.4u AS=2.04p AD=5.1p PS=4.6u PD=6.4u
M_d_604 _n_201 _n_31 VSS VSS NMOS_mst L=1u W=13.6u AS=20.4p AD=24.82p PS=25.6u PD=31.6u
M_d_608 _n_90 A3n _n_50 VSS NMOS_mst L=1u W=3.4u AS=9.52p AD=2.04p PS=12.4u PD=4.6u
M_d_609 _n_92 A2p _n_90 VSS NMOS_mst L=1u W=3.4u AS=2.04p AD=2.04p PS=4.6u PD=4.6u
M_d_610 _n_91 A1n _n_92 VSS NMOS_mst L=1u W=3.4u AS=2.04p AD=2.04p PS=4.6u PD=4.6u
M_d_611 _n_177 A0p _n_91 VSS NMOS_mst L=1u W=3.4u AS=2.04p AD=2.04p PS=4.6u PD=4.6u
M_d_612 VSS PR0 _n_177 VSS NMOS_mst L=1u W=3.4u AS=2.04p AD=5.1p PS=4.6u PD=6.4u
M_d_613 _n_202 _n_50 VSS VSS NMOS_mst L=1u W=13.6u AS=20.4p AD=24.82p PS=25.6u PD=31.6u
M_d_617 _n_108 A3p _n_33 VSS NMOS_mst L=1u W=3.4u AS=9.52p AD=2.04p PS=12.4u PD=4.6u
M_d_618 _n_110 A2n _n_108 VSS NMOS_mst L=1u W=3.4u AS=2.04p AD=2.04p PS=4.6u PD=4.6u
M_d_619 _n_109 A1n _n_110 VSS NMOS_mst L=1u W=3.4u AS=2.04p AD=2.04p PS=4.6u PD=4.6u
M_d_620 _n_183 A0n _n_109 VSS NMOS_mst L=1u W=3.4u AS=2.04p AD=2.04p PS=4.6u PD=4.6u
M_d_621 VSS PR0 _n_183 VSS NMOS_mst L=1u W=3.4u AS=2.04p AD=5.1p PS=4.6u PD=6.4u
M_d_622 _n_205 _n_33 VSS VSS NMOS_mst L=1u W=13.6u AS=20.4p AD=24.82p PS=25.6u PD=31.6u
M_d_626 _n_115 A3p _n_52 VSS NMOS_mst L=1u W=3.4u AS=9.52p AD=2.04p PS=12.4u PD=4.6u
M_d_627 _n_114 A2n _n_115 VSS NMOS_mst L=1u W=3.4u AS=2.04p AD=2.04p PS=4.6u PD=4.6u
M_d_628 _n_116 A1n _n_114 VSS NMOS_mst L=1u W=3.4u AS=2.04p AD=2.04p PS=4.6u PD=4.6u
M_d_629 _n_186 A0p _n_116 VSS NMOS_mst L=1u W=3.4u AS=2.04p AD=2.04p PS=4.6u PD=4.6u
M_d_630 VSS PR0 _n_186 VSS NMOS_mst L=1u W=3.4u AS=2.04p AD=5.1p PS=4.6u PD=6.4u
M_d_631 _n_206 _n_52 VSS VSS NMOS_mst L=1u W=13.6u AS=20.4p AD=24.82p PS=25.6u PD=31.6u
M_d_635 _n_120 A3p _n_34 VSS NMOS_mst L=1u W=3.4u AS=9.52p AD=2.04p PS=12.4u PD=4.6u
M_d_636 _n_122 A2n _n_120 VSS NMOS_mst L=1u W=3.4u AS=2.04p AD=2.04p PS=4.6u PD=4.6u
M_d_637 _n_121 A1p _n_122 VSS NMOS_mst L=1u W=3.4u AS=2.04p AD=2.04p PS=4.6u PD=4.6u
M_d_638 _n_188 A0n _n_121 VSS NMOS_mst L=1u W=3.4u AS=2.04p AD=2.04p PS=4.6u PD=4.6u
M_d_639 VSS PR0 _n_188 VSS NMOS_mst L=1u W=3.4u AS=2.04p AD=5.1p PS=4.6u PD=6.4u
M_d_640 _n_207 _n_34 VSS VSS NMOS_mst L=1u W=13.6u AS=20.4p AD=24.82p PS=25.6u PD=31.6u
M_d_644 _n_127 A3p _n_53 VSS NMOS_mst L=1u W=3.4u AS=9.52p AD=2.04p PS=12.4u PD=4.6u
M_d_645 _n_130 A2n _n_127 VSS NMOS_mst L=1u W=3.4u AS=2.04p AD=2.04p PS=4.6u PD=4.6u
M_d_646 _n_128 A1p _n_130 VSS NMOS_mst L=1u W=3.4u AS=2.04p AD=2.04p PS=4.6u PD=4.6u
M_d_647 _n_191 A0p _n_128 VSS NMOS_mst L=1u W=3.4u AS=2.04p AD=2.04p PS=4.6u PD=4.6u
M_d_648 VSS PR0 _n_191 VSS NMOS_mst L=1u W=3.4u AS=2.04p AD=5.1p PS=4.6u PD=6.4u
M_d_649 _n_208 _n_53 VSS VSS NMOS_mst L=1u W=13.6u AS=20.4p AD=24.82p PS=25.6u PD=31.6u
M_d_653 _n_134 A3p _n_35 VSS NMOS_mst L=1u W=3.4u AS=9.52p AD=2.04p PS=12.4u PD=4.6u
M_d_654 _n_132 A2p _n_134 VSS NMOS_mst L=1u W=3.4u AS=2.04p AD=2.04p PS=4.6u PD=4.6u
M_d_655 _n_133 A1n _n_132 VSS NMOS_mst L=1u W=3.4u AS=2.04p AD=2.04p PS=4.6u PD=4.6u
M_d_656 _n_192 A0n _n_133 VSS NMOS_mst L=1u W=3.4u AS=2.04p AD=2.04p PS=4.6u PD=4.6u
M_d_657 VSS PR0 _n_192 VSS NMOS_mst L=1u W=3.4u AS=2.04p AD=5.1p PS=4.6u PD=6.4u
M_d_658 _n_209 _n_35 VSS VSS NMOS_mst L=1u W=13.6u AS=20.4p AD=24.82p PS=25.6u PD=31.6u
M_d_662 _n_144 A3p _n_36 VSS NMOS_mst L=1u W=3.4u AS=9.52p AD=2.04p PS=12.4u PD=4.6u
M_d_663 _n_145 A2p _n_144 VSS NMOS_mst L=1u W=3.4u AS=2.04p AD=2.04p PS=4.6u PD=4.6u
M_d_664 _n_146 A1p _n_145 VSS NMOS_mst L=1u W=3.4u AS=2.04p AD=2.04p PS=4.6u PD=4.6u
M_d_665 _n_193 A0n _n_146 VSS NMOS_mst L=1u W=3.4u AS=2.04p AD=2.04p PS=4.6u PD=4.6u
M_d_666 VSS PR0 _n_193 VSS NMOS_mst L=1u W=3.4u AS=2.04p AD=5.1p PS=4.6u PD=6.4u
M_d_667 _n_211 _n_36 VSS VSS NMOS_mst L=1u W=13.6u AS=20.4p AD=24.82p PS=25.6u PD=31.6u
M_d_671 _n_151 A3p _n_55 VSS NMOS_mst L=1u W=3.4u AS=9.52p AD=2.04p PS=12.4u PD=4.6u
M_d_672 _n_152 A2p _n_151 VSS NMOS_mst L=1u W=3.4u AS=2.04p AD=2.04p PS=4.6u PD=4.6u
M_d_673 _n_154 A1p _n_152 VSS NMOS_mst L=1u W=3.4u AS=2.04p AD=2.04p PS=4.6u PD=4.6u
M_d_674 _n_190 A0p _n_154 VSS NMOS_mst L=1u W=3.4u AS=2.04p AD=2.04p PS=4.6u PD=4.6u
M_d_675 VSS PR0 _n_190 VSS NMOS_mst L=1u W=3.4u AS=2.04p AD=5.1p PS=4.6u PD=6.4u
M_d_676 _n_212 _n_55 VSS VSS NMOS_mst L=1u W=13.6u AS=20.4p AD=24.82p PS=25.6u PD=31.6u
M_d_680 _n_158 A3n _n_37 VSS NMOS_mst L=1u W=3.4u AS=9.52p AD=2.04p PS=12.4u PD=4.6u
M_d_681 _n_157 A2n _n_158 VSS NMOS_mst L=1u W=3.4u AS=2.04p AD=2.04p PS=4.6u PD=4.6u
M_d_682 _n_156 A1n _n_157 VSS NMOS_mst L=1u W=3.4u AS=2.04p AD=2.04p PS=4.6u PD=4.6u
M_d_683 _n_189 A0n _n_156 VSS NMOS_mst L=1u W=3.4u AS=2.04p AD=2.04p PS=4.6u PD=4.6u
M_d_684 VSS PR1 _n_189 VSS NMOS_mst L=1u W=3.4u AS=2.04p AD=5.1p PS=4.6u PD=6.4u
M_d_685 _n_213 _n_37 VSS VSS NMOS_mst L=1u W=13.6u AS=20.4p AD=24.82p PS=25.6u PD=31.6u
M_d_689 _n_161 A3n _n_56 VSS NMOS_mst L=1u W=3.4u AS=9.52p AD=2.04p PS=12.4u PD=4.6u
M_d_690 _n_159 A2n _n_161 VSS NMOS_mst L=1u W=3.4u AS=2.04p AD=2.04p PS=4.6u PD=4.6u
M_d_691 _n_160 A1n _n_159 VSS NMOS_mst L=1u W=3.4u AS=2.04p AD=2.04p PS=4.6u PD=4.6u
M_d_692 _n_187 A0p _n_160 VSS NMOS_mst L=1u W=3.4u AS=2.04p AD=2.04p PS=4.6u PD=4.6u
M_d_693 VSS PR1 _n_187 VSS NMOS_mst L=1u W=3.4u AS=2.04p AD=5.1p PS=4.6u PD=6.4u
M_d_694 _n_214 _n_56 VSS VSS NMOS_mst L=1u W=13.6u AS=20.4p AD=24.82p PS=25.6u PD=31.6u
M_d_698 _n_153 A3n _n_38 VSS NMOS_mst L=1u W=3.4u AS=9.52p AD=2.04p PS=12.4u PD=4.6u
M_d_699 _n_150 A2n _n_153 VSS NMOS_mst L=1u W=3.4u AS=2.04p AD=2.04p PS=4.6u PD=4.6u
M_d_700 _n_155 A1p _n_150 VSS NMOS_mst L=1u W=3.4u AS=2.04p AD=2.04p PS=4.6u PD=4.6u
M_d_701 _n_185 A0n _n_155 VSS NMOS_mst L=1u W=3.4u AS=2.04p AD=2.04p PS=4.6u PD=4.6u
M_d_702 VSS PR1 _n_185 VSS NMOS_mst L=1u W=3.4u AS=2.04p AD=5.1p PS=4.6u PD=6.4u
M_d_703 _n_215 _n_38 VSS VSS NMOS_mst L=1u W=13.6u AS=20.4p AD=24.82p PS=25.6u PD=31.6u
M_d_707 _n_142 A3n _n_39 VSS NMOS_mst L=1u W=3.4u AS=9.52p AD=2.04p PS=12.4u PD=4.6u
M_d_708 _n_143 A2p _n_142 VSS NMOS_mst L=1u W=3.4u AS=2.04p AD=2.04p PS=4.6u PD=4.6u
M_d_709 _n_141 A1n _n_143 VSS NMOS_mst L=1u W=3.4u AS=2.04p AD=2.04p PS=4.6u PD=4.6u
M_d_710 _n_182 A0n _n_141 VSS NMOS_mst L=1u W=3.4u AS=2.04p AD=2.04p PS=4.6u PD=4.6u
M_d_711 VSS PR1 _n_182 VSS NMOS_mst L=1u W=3.4u AS=2.04p AD=5.1p PS=4.6u PD=6.4u
M_d_712 _n_217 _n_39 VSS VSS NMOS_mst L=1u W=13.6u AS=20.4p AD=24.82p PS=25.6u PD=31.6u
M_d_716 _n_136 A3n _n_58 VSS NMOS_mst L=1u W=3.4u AS=9.52p AD=2.04p PS=12.4u PD=4.6u
M_d_717 _n_135 A2p _n_136 VSS NMOS_mst L=1u W=3.4u AS=2.04p AD=2.04p PS=4.6u PD=4.6u
M_d_718 _n_137 A1n _n_135 VSS NMOS_mst L=1u W=3.4u AS=2.04p AD=2.04p PS=4.6u PD=4.6u
M_d_719 _n_180 A0p _n_137 VSS NMOS_mst L=1u W=3.4u AS=2.04p AD=2.04p PS=4.6u PD=4.6u
M_d_720 VSS PR1 _n_180 VSS NMOS_mst L=1u W=3.4u AS=2.04p AD=5.1p PS=4.6u PD=6.4u
M_d_721 _n_218 _n_58 VSS VSS NMOS_mst L=1u W=13.6u AS=20.4p AD=24.82p PS=25.6u PD=31.6u
M_d_725 _n_129 A3n _n_40 VSS NMOS_mst L=1u W=3.4u AS=9.52p AD=2.04p PS=12.4u PD=4.6u
M_d_726 _n_126 A2p _n_129 VSS NMOS_mst L=1u W=3.4u AS=2.04p AD=2.04p PS=4.6u PD=4.6u
M_d_727 _n_131 A1p _n_126 VSS NMOS_mst L=1u W=3.4u AS=2.04p AD=2.04p PS=4.6u PD=4.6u
M_d_728 _n_179 A0n _n_131 VSS NMOS_mst L=1u W=3.4u AS=2.04p AD=2.04p PS=4.6u PD=4.6u
M_d_729 VSS PR1 _n_179 VSS NMOS_mst L=1u W=3.4u AS=2.04p AD=5.1p PS=4.6u PD=6.4u
M_d_730 _n_219 _n_40 VSS VSS NMOS_mst L=1u W=13.6u AS=20.4p AD=24.82p PS=25.6u PD=31.6u
M_d_734 _n_124 A3n _n_59 VSS NMOS_mst L=1u W=3.4u AS=9.52p AD=2.04p PS=12.4u PD=4.6u
M_d_735 _n_123 A2p _n_124 VSS NMOS_mst L=1u W=3.4u AS=2.04p AD=2.04p PS=4.6u PD=4.6u
M_d_736 _n_125 A1p _n_123 VSS NMOS_mst L=1u W=3.4u AS=2.04p AD=2.04p PS=4.6u PD=4.6u
M_d_737 _n_176 A0p _n_125 VSS NMOS_mst L=1u W=3.4u AS=2.04p AD=2.04p PS=4.6u PD=4.6u
M_d_738 VSS PR1 _n_176 VSS NMOS_mst L=1u W=3.4u AS=2.04p AD=5.1p PS=4.6u PD=6.4u
M_d_739 _n_220 _n_59 VSS VSS NMOS_mst L=1u W=13.6u AS=20.4p AD=24.82p PS=25.6u PD=31.6u
M_d_743 _n_118 A3p _n_41 VSS NMOS_mst L=1u W=3.4u AS=9.52p AD=2.04p PS=12.4u PD=4.6u
M_d_744 _n_117 A2n _n_118 VSS NMOS_mst L=1u W=3.4u AS=2.04p AD=2.04p PS=4.6u PD=4.6u
M_d_745 _n_119 A1n _n_117 VSS NMOS_mst L=1u W=3.4u AS=2.04p AD=2.04p PS=4.6u PD=4.6u
M_d_746 _n_175 A0n _n_119 VSS NMOS_mst L=1u W=3.4u AS=2.04p AD=2.04p PS=4.6u PD=4.6u
M_d_747 VSS PR1 _n_175 VSS NMOS_mst L=1u W=3.4u AS=2.04p AD=5.1p PS=4.6u PD=6.4u
M_d_748 _n_221 _n_41 VSS VSS NMOS_mst L=1u W=13.6u AS=20.4p AD=24.82p PS=25.6u PD=31.6u
M_d_752 _n_102 A3p _n_42 VSS NMOS_mst L=1u W=3.4u AS=9.52p AD=2.04p PS=12.4u PD=4.6u
M_d_753 _n_107 A2n _n_102 VSS NMOS_mst L=1u W=3.4u AS=2.04p AD=2.04p PS=4.6u PD=4.6u
M_d_754 _n_104 A1p _n_107 VSS NMOS_mst L=1u W=3.4u AS=2.04p AD=2.04p PS=4.6u PD=4.6u
M_d_755 _n_172 A0n _n_104 VSS NMOS_mst L=1u W=3.4u AS=2.04p AD=2.04p PS=4.6u PD=4.6u
M_d_756 VSS PR1 _n_172 VSS NMOS_mst L=1u W=3.4u AS=2.04p AD=5.1p PS=4.6u PD=6.4u
M_d_757 _n_223 _n_42 VSS VSS NMOS_mst L=1u W=13.6u AS=20.4p AD=24.82p PS=25.6u PD=31.6u
M_d_761 _n_87 A3p _n_62 VSS NMOS_mst L=1u W=3.4u AS=9.52p AD=2.04p PS=12.4u PD=4.6u
M_d_762 _n_89 A2p _n_87 VSS NMOS_mst L=1u W=3.4u AS=2.04p AD=2.04p PS=4.6u PD=4.6u
M_d_763 _n_88 A1n _n_89 VSS NMOS_mst L=1u W=3.4u AS=2.04p AD=2.04p PS=4.6u PD=4.6u
M_d_764 _n_166 A0p _n_88 VSS NMOS_mst L=1u W=3.4u AS=2.04p AD=2.04p PS=4.6u PD=4.6u
M_d_765 VSS PR1 _n_166 VSS NMOS_mst L=1u W=3.4u AS=2.04p AD=5.1p PS=4.6u PD=6.4u
M_d_766 _n_226 _n_62 VSS VSS NMOS_mst L=1u W=13.6u AS=20.4p AD=24.82p PS=25.6u PD=31.6u
M_d_770 _n_83 A3p _n_44 VSS NMOS_mst L=1u W=3.4u AS=9.52p AD=2.04p PS=12.4u PD=4.6u
M_d_771 _n_78 A2p _n_83 VSS NMOS_mst L=1u W=3.4u AS=2.04p AD=2.04p PS=4.6u PD=4.6u
M_d_772 _n_82 A1p _n_78 VSS NMOS_mst L=1u W=3.4u AS=2.04p AD=2.04p PS=4.6u PD=4.6u
M_d_773 _n_165 A0n _n_82 VSS NMOS_mst L=1u W=3.4u AS=2.04p AD=2.04p PS=4.6u PD=4.6u
M_d_774 VSS PR1 _n_165 VSS NMOS_mst L=1u W=3.4u AS=2.04p AD=5.1p PS=4.6u PD=6.4u
M_d_775 _n_227 _n_44 VSS VSS NMOS_mst L=1u W=13.6u AS=20.4p AD=24.82p PS=25.6u PD=31.6u
M_d_779 _n_75 A3p _n_63 VSS NMOS_mst L=1u W=3.4u AS=9.52p AD=2.04p PS=12.4u PD=4.6u
M_d_780 _n_77 A2p _n_75 VSS NMOS_mst L=1u W=3.4u AS=2.04p AD=2.04p PS=4.6u PD=4.6u
M_d_781 _n_76 A1p _n_77 VSS NMOS_mst L=1u W=3.4u AS=2.04p AD=2.04p PS=4.6u PD=4.6u
M_d_782 _n_163 A0p _n_76 VSS NMOS_mst L=1u W=3.4u AS=2.04p AD=2.04p PS=4.6u PD=4.6u
M_d_783 VSS PR1 _n_163 VSS NMOS_mst L=1u W=3.4u AS=2.04p AD=5.1p PS=4.6u PD=6.4u
M_d_784 _n_228 _n_63 VSS VSS NMOS_mst L=1u W=13.6u AS=20.4p AD=24.82p PS=25.6u PD=31.6u
M_d_788 _n_96 A3n _n_32 VSS NMOS_mst L=1u W=3.4u AS=9.52p AD=2.04p PS=12.4u PD=4.6u
M_d_789 _n_98 A2p _n_96 VSS NMOS_mst L=1u W=3.4u AS=2.04p AD=2.04p PS=4.6u PD=4.6u
M_d_790 _n_97 A1p _n_98 VSS NMOS_mst L=1u W=3.4u AS=2.04p AD=2.04p PS=4.6u PD=4.6u
M_d_791 _n_178 A0n _n_97 VSS NMOS_mst L=1u W=3.4u AS=2.04p AD=2.04p PS=4.6u PD=4.6u
M_d_792 VSS PR0 _n_178 VSS NMOS_mst L=1u W=3.4u AS=2.04p AD=5.1p PS=4.6u PD=6.4u
M_d_793 _n_203 _n_32 VSS VSS NMOS_mst L=1u W=13.6u AS=20.4p AD=24.82p PS=25.6u PD=31.6u
M_d_797 _n_103 A3n _n_51 VSS NMOS_mst L=1u W=3.4u AS=9.52p AD=2.04p PS=12.4u PD=4.6u
M_d_798 _n_106 A2p _n_103 VSS NMOS_mst L=1u W=3.4u AS=2.04p AD=2.04p PS=4.6u PD=4.6u
M_d_799 _n_105 A1p _n_106 VSS NMOS_mst L=1u W=3.4u AS=2.04p AD=2.04p PS=4.6u PD=4.6u
M_d_800 _n_181 A0p _n_105 VSS NMOS_mst L=1u W=3.4u AS=2.04p AD=2.04p PS=4.6u PD=4.6u
M_d_801 VSS PR0 _n_181 VSS NMOS_mst L=1u W=3.4u AS=2.04p AD=5.1p PS=4.6u PD=6.4u
M_d_802 _n_204 _n_51 VSS VSS NMOS_mst L=1u W=13.6u AS=20.4p AD=24.82p PS=25.6u PD=31.6u
M_d_806 _n_139 A3p _n_54 VSS NMOS_mst L=1u W=3.4u AS=9.52p AD=2.04p PS=12.4u PD=4.6u
M_d_807 _n_140 A2p _n_139 VSS NMOS_mst L=1u W=3.4u AS=2.04p AD=2.04p PS=4.6u PD=4.6u
M_d_808 _n_138 A1n _n_140 VSS NMOS_mst L=1u W=3.4u AS=2.04p AD=2.04p PS=4.6u PD=4.6u
M_d_809 _n_194 A0p _n_138 VSS NMOS_mst L=1u W=3.4u AS=2.04p AD=2.04p PS=4.6u PD=4.6u
M_d_810 VSS PR0 _n_194 VSS NMOS_mst L=1u W=3.4u AS=2.04p AD=5.1p PS=4.6u PD=6.4u
M_d_811 _n_210 _n_54 VSS VSS NMOS_mst L=1u W=13.6u AS=20.4p AD=24.82p PS=25.6u PD=31.6u
M_d_815 _n_147 A3n _n_57 VSS NMOS_mst L=1u W=3.4u AS=9.52p AD=2.04p PS=12.4u PD=4.6u
M_d_816 _n_149 A2n _n_147 VSS NMOS_mst L=1u W=3.4u AS=2.04p AD=2.04p PS=4.6u PD=4.6u
M_d_817 _n_148 A1p _n_149 VSS NMOS_mst L=1u W=3.4u AS=2.04p AD=2.04p PS=4.6u PD=4.6u
M_d_818 _n_184 A0p _n_148 VSS NMOS_mst L=1u W=3.4u AS=2.04p AD=2.04p PS=4.6u PD=4.6u
M_d_819 VSS PR1 _n_184 VSS NMOS_mst L=1u W=3.4u AS=2.04p AD=5.1p PS=4.6u PD=6.4u
M_d_820 _n_216 _n_57 VSS VSS NMOS_mst L=1u W=13.6u AS=20.4p AD=24.82p PS=25.6u PD=31.6u
M_d_824 _n_111 A3p _n_60 VSS NMOS_mst L=1u W=3.4u AS=9.52p AD=2.04p PS=12.4u PD=4.6u
M_d_825 _n_113 A2n _n_111 VSS NMOS_mst L=1u W=3.4u AS=2.04p AD=2.04p PS=4.6u PD=4.6u
M_d_826 _n_112 A1n _n_113 VSS NMOS_mst L=1u W=3.4u AS=2.04p AD=2.04p PS=4.6u PD=4.6u
M_d_827 _n_174 A0p _n_112 VSS NMOS_mst L=1u W=3.4u AS=2.04p AD=2.04p PS=4.6u PD=4.6u
M_d_828 VSS PR1 _n_174 VSS NMOS_mst L=1u W=3.4u AS=2.04p AD=5.1p PS=4.6u PD=6.4u
M_d_829 _n_222 _n_60 VSS VSS NMOS_mst L=1u W=13.6u AS=20.4p AD=24.82p PS=25.6u PD=31.6u
M_d_833 _n_99 A3p _n_61 VSS NMOS_mst L=1u W=3.4u AS=9.52p AD=2.04p PS=12.4u PD=4.6u
M_d_834 _n_100 A2n _n_99 VSS NMOS_mst L=1u W=3.4u AS=2.04p AD=2.04p PS=4.6u PD=4.6u
M_d_835 _n_101 A1p _n_100 VSS NMOS_mst L=1u W=3.4u AS=2.04p AD=2.04p PS=4.6u PD=4.6u
M_d_836 _n_170 A0p _n_101 VSS NMOS_mst L=1u W=3.4u AS=2.04p AD=2.04p PS=4.6u PD=4.6u
M_d_837 VSS PR1 _n_170 VSS NMOS_mst L=1u W=3.4u AS=2.04p AD=5.1p PS=4.6u PD=6.4u
M_d_838 _n_224 _n_61 VSS VSS NMOS_mst L=1u W=13.6u AS=20.4p AD=24.82p PS=25.6u PD=31.6u
M_d_842 _n_93 A3p _n_43 VSS NMOS_mst L=1u W=3.4u AS=9.52p AD=2.04p PS=12.4u PD=4.6u
M_d_843 _n_94 A2p _n_93 VSS NMOS_mst L=1u W=3.4u AS=2.04p AD=2.04p PS=4.6u PD=4.6u
M_d_844 _n_95 A1n _n_94 VSS NMOS_mst L=1u W=3.4u AS=2.04p AD=2.04p PS=4.6u PD=4.6u
M_d_845 _n_169 A0n _n_95 VSS NMOS_mst L=1u W=3.4u AS=2.04p AD=2.04p PS=4.6u PD=4.6u
M_d_846 VSS PR1 _n_169 VSS NMOS_mst L=1u W=3.4u AS=2.04p AD=5.1p PS=4.6u PD=6.4u
M_d_847 _n_225 _n_43 VSS VSS NMOS_mst L=1u W=13.6u AS=20.4p AD=24.82p PS=25.6u PD=31.6u
M_d_851 _n_68 _n_46 VSS VSS NMOS_mst L=1u W=6.8u AS=19.04p AD=4.08p PS=19.2u PD=8u
M_d_852 PRn _n_64 _n_68 VSS NMOS_mst L=1u W=6.8u AS=4.08p AD=19.04p PS=8u PD=19.2u
M_d_853 VSS CE_CEp _n_162 VSS NMOS_mst L=1u W=3.4u AS=9.52p AD=5.1p PS=12.4u PD=6.4u
M_d_854 _n_233 _n_162 VSS VSS NMOS_mst L=1u W=3.4u AS=5.1p AD=9.52p PS=6.4u PD=12.4u
M_d_855 WRn WRp VSS VSS NMOS_mst L=1u W=6.8u AS=14.62p AD=14.62p PS=18.8u PD=18.8u
M_d_857 _n_235 _n_229 LATp VSS NMOS_mst L=1u W=6.8u AS=19.04p AD=4.08p PS=19.2u PD=8u
M_d_858 VSS PRn _n_235 VSS NMOS_mst L=1u W=6.8u AS=4.08p AD=19.04p PS=8u PD=19.2u
M_d_859 VSS _n_231 _n_232 VSS NMOS_mst L=2u W=3.4u AS=9.52p AD=8.5p PS=12.4u PD=8.4u
M_d_860 _n_229 _n_232 VSS VSS NMOS_mst L=1u W=3.4u AS=8.5p AD=5.1p PS=8.4u PD=6.4u
M_d_861 VSS WR _n_229 VSS NMOS_mst L=1u W=3.4u AS=5.1p AD=9.52p PS=6.4u PD=12.4u
M_d_862 _n_236 _n_233 _n_234 VSS NMOS_mst L=1u W=3.4u AS=9.52p AD=2.04p PS=12.4u PD=4.6u
M_d_863 VSS WR _n_236 VSS NMOS_mst L=1u W=3.4u AS=2.04p AD=9.52p PS=4.6u PD=12.4u
M_d_864 WRp _n_234 VSS VSS NMOS_mst L=1u W=6.8u AS=14.62p AD=14.62p PS=18.8u PD=18.8u
M_d_866 _n_240 _n_197 BLn[0] VSS NMOS_mst L=1u W=3.4u AS=9.52p AD=5.1p PS=12.4u PD=6.4u
M_d_867 VSS _n_296 _n_240 VSS NMOS_mst L=1u W=3.4u AS=5.1p AD=5.1p PS=6.4u PD=6.4u
M_d_868 _n_296 _n_240 VSS VSS NMOS_mst L=1u W=3.4u AS=5.1p AD=5.1p PS=6.4u PD=6.4u
M_d_869 BLp[0] _n_197 _n_296 VSS NMOS_mst L=1u W=3.4u AS=5.1p AD=9.52p PS=6.4u PD=12.4u
M_d_870 _n_241 _n_198 BLn[0] VSS NMOS_mst L=1u W=3.4u AS=9.52p AD=5.1p PS=12.4u PD=6.4u
M_d_871 VSS _n_276 _n_241 VSS NMOS_mst L=1u W=3.4u AS=5.1p AD=5.1p PS=6.4u PD=6.4u
M_d_872 _n_276 _n_241 VSS VSS NMOS_mst L=1u W=3.4u AS=5.1p AD=5.1p PS=6.4u PD=6.4u
M_d_873 BLp[0] _n_198 _n_276 VSS NMOS_mst L=1u W=3.4u AS=5.1p AD=9.52p PS=6.4u PD=12.4u
M_d_874 _n_242 _n_199 BLn[0] VSS NMOS_mst L=1u W=3.4u AS=9.52p AD=5.1p PS=12.4u PD=6.4u
M_d_875 VSS _n_297 _n_242 VSS NMOS_mst L=1u W=3.4u AS=5.1p AD=5.1p PS=6.4u PD=6.4u
M_d_876 _n_297 _n_242 VSS VSS NMOS_mst L=1u W=3.4u AS=5.1p AD=5.1p PS=6.4u PD=6.4u
M_d_877 BLp[0] _n_199 _n_297 VSS NMOS_mst L=1u W=3.4u AS=5.1p AD=9.52p PS=6.4u PD=12.4u
M_d_878 _n_244 _n_201 BLn[0] VSS NMOS_mst L=1u W=3.4u AS=9.52p AD=5.1p PS=12.4u PD=6.4u
M_d_879 VSS _n_298 _n_244 VSS NMOS_mst L=1u W=3.4u AS=5.1p AD=5.1p PS=6.4u PD=6.4u
M_d_880 _n_298 _n_244 VSS VSS NMOS_mst L=1u W=3.4u AS=5.1p AD=5.1p PS=6.4u PD=6.4u
M_d_881 BLp[0] _n_201 _n_298 VSS NMOS_mst L=1u W=3.4u AS=5.1p AD=9.52p PS=6.4u PD=12.4u
M_d_882 _n_245 _n_202 BLn[0] VSS NMOS_mst L=1u W=3.4u AS=9.52p AD=5.1p PS=12.4u PD=6.4u
M_d_883 VSS _n_278 _n_245 VSS NMOS_mst L=1u W=3.4u AS=5.1p AD=5.1p PS=6.4u PD=6.4u
M_d_884 _n_278 _n_245 VSS VSS NMOS_mst L=1u W=3.4u AS=5.1p AD=5.1p PS=6.4u PD=6.4u
M_d_885 BLp[0] _n_202 _n_278 VSS NMOS_mst L=1u W=3.4u AS=5.1p AD=9.52p PS=6.4u PD=12.4u
M_d_886 _n_246 _n_203 BLn[0] VSS NMOS_mst L=1u W=3.4u AS=9.52p AD=5.1p PS=12.4u PD=6.4u
M_d_887 VSS _n_299 _n_246 VSS NMOS_mst L=1u W=3.4u AS=5.1p AD=5.1p PS=6.4u PD=6.4u
M_d_888 _n_299 _n_246 VSS VSS NMOS_mst L=1u W=3.4u AS=5.1p AD=5.1p PS=6.4u PD=6.4u
M_d_889 BLp[0] _n_203 _n_299 VSS NMOS_mst L=1u W=3.4u AS=5.1p AD=9.52p PS=6.4u PD=12.4u
M_d_890 _n_247 _n_204 BLn[0] VSS NMOS_mst L=1u W=3.4u AS=9.52p AD=5.1p PS=12.4u PD=6.4u
M_d_891 VSS _n_279 _n_247 VSS NMOS_mst L=1u W=3.4u AS=5.1p AD=5.1p PS=6.4u PD=6.4u
M_d_892 _n_279 _n_247 VSS VSS NMOS_mst L=1u W=3.4u AS=5.1p AD=5.1p PS=6.4u PD=6.4u
M_d_893 BLp[0] _n_204 _n_279 VSS NMOS_mst L=1u W=3.4u AS=5.1p AD=9.52p PS=6.4u PD=12.4u
M_d_894 _n_248 _n_205 BLn[0] VSS NMOS_mst L=1u W=3.4u AS=9.52p AD=5.1p PS=12.4u PD=6.4u
M_d_895 VSS _n_300 _n_248 VSS NMOS_mst L=1u W=3.4u AS=5.1p AD=5.1p PS=6.4u PD=6.4u
M_d_896 _n_300 _n_248 VSS VSS NMOS_mst L=1u W=3.4u AS=5.1p AD=5.1p PS=6.4u PD=6.4u
M_d_897 BLp[0] _n_205 _n_300 VSS NMOS_mst L=1u W=3.4u AS=5.1p AD=9.52p PS=6.4u PD=12.4u
M_d_898 _n_249 _n_206 BLn[0] VSS NMOS_mst L=1u W=3.4u AS=9.52p AD=5.1p PS=12.4u PD=6.4u
M_d_899 VSS _n_280 _n_249 VSS NMOS_mst L=1u W=3.4u AS=5.1p AD=5.1p PS=6.4u PD=6.4u
M_d_900 _n_280 _n_249 VSS VSS NMOS_mst L=1u W=3.4u AS=5.1p AD=5.1p PS=6.4u PD=6.4u
M_d_901 BLp[0] _n_206 _n_280 VSS NMOS_mst L=1u W=3.4u AS=5.1p AD=9.52p PS=6.4u PD=12.4u
M_d_902 _n_250 _n_207 BLn[0] VSS NMOS_mst L=1u W=3.4u AS=9.52p AD=5.1p PS=12.4u PD=6.4u
M_d_903 VSS _n_301 _n_250 VSS NMOS_mst L=1u W=3.4u AS=5.1p AD=5.1p PS=6.4u PD=6.4u
M_d_904 _n_301 _n_250 VSS VSS NMOS_mst L=1u W=3.4u AS=5.1p AD=5.1p PS=6.4u PD=6.4u
M_d_905 BLp[0] _n_207 _n_301 VSS NMOS_mst L=1u W=3.4u AS=5.1p AD=9.52p PS=6.4u PD=12.4u
M_d_906 _n_252 _n_209 BLn[0] VSS NMOS_mst L=1u W=3.4u AS=9.52p AD=5.1p PS=12.4u PD=6.4u
M_d_907 VSS _n_302 _n_252 VSS NMOS_mst L=1u W=3.4u AS=5.1p AD=5.1p PS=6.4u PD=6.4u
M_d_908 _n_302 _n_252 VSS VSS NMOS_mst L=1u W=3.4u AS=5.1p AD=5.1p PS=6.4u PD=6.4u
M_d_909 BLp[0] _n_209 _n_302 VSS NMOS_mst L=1u W=3.4u AS=5.1p AD=9.52p PS=6.4u PD=12.4u
M_d_910 _n_255 _n_212 BLn[0] VSS NMOS_mst L=1u W=3.4u AS=9.52p AD=5.1p PS=12.4u PD=6.4u
M_d_911 VSS _n_283 _n_255 VSS NMOS_mst L=1u W=3.4u AS=5.1p AD=5.1p PS=6.4u PD=6.4u
M_d_912 _n_283 _n_255 VSS VSS NMOS_mst L=1u W=3.4u AS=5.1p AD=5.1p PS=6.4u PD=6.4u
M_d_913 BLp[0] _n_212 _n_283 VSS NMOS_mst L=1u W=3.4u AS=5.1p AD=9.52p PS=6.4u PD=12.4u
M_d_914 _n_257 _n_214 BLn[0] VSS NMOS_mst L=1u W=3.4u AS=9.52p AD=5.1p PS=12.4u PD=6.4u
M_d_915 VSS _n_284 _n_257 VSS NMOS_mst L=1u W=3.4u AS=5.1p AD=5.1p PS=6.4u PD=6.4u
M_d_916 _n_284 _n_257 VSS VSS NMOS_mst L=1u W=3.4u AS=5.1p AD=5.1p PS=6.4u PD=6.4u
M_d_917 BLp[0] _n_214 _n_284 VSS NMOS_mst L=1u W=3.4u AS=5.1p AD=9.52p PS=6.4u PD=12.4u
M_d_918 _n_258 _n_215 BLn[0] VSS NMOS_mst L=1u W=3.4u AS=9.52p AD=5.1p PS=12.4u PD=6.4u
M_d_919 VSS _n_305 _n_258 VSS NMOS_mst L=1u W=3.4u AS=5.1p AD=5.1p PS=6.4u PD=6.4u
M_d_920 _n_305 _n_258 VSS VSS NMOS_mst L=1u W=3.4u AS=5.1p AD=5.1p PS=6.4u PD=6.4u
M_d_921 BLp[0] _n_215 _n_305 VSS NMOS_mst L=1u W=3.4u AS=5.1p AD=9.52p PS=6.4u PD=12.4u
M_d_922 _n_260 _n_217 BLn[0] VSS NMOS_mst L=1u W=3.4u AS=9.52p AD=5.1p PS=12.4u PD=6.4u
M_d_923 VSS _n_306 _n_260 VSS NMOS_mst L=1u W=3.4u AS=5.1p AD=5.1p PS=6.4u PD=6.4u
M_d_924 _n_306 _n_260 VSS VSS NMOS_mst L=1u W=3.4u AS=5.1p AD=5.1p PS=6.4u PD=6.4u
M_d_925 BLp[0] _n_217 _n_306 VSS NMOS_mst L=1u W=3.4u AS=5.1p AD=9.52p PS=6.4u PD=12.4u
M_d_926 _n_261 _n_218 BLn[0] VSS NMOS_mst L=1u W=3.4u AS=9.52p AD=5.1p PS=12.4u PD=6.4u
M_d_927 VSS _n_286 _n_261 VSS NMOS_mst L=1u W=3.4u AS=5.1p AD=5.1p PS=6.4u PD=6.4u
M_d_928 _n_286 _n_261 VSS VSS NMOS_mst L=1u W=3.4u AS=5.1p AD=5.1p PS=6.4u PD=6.4u
M_d_929 BLp[0] _n_218 _n_286 VSS NMOS_mst L=1u W=3.4u AS=5.1p AD=9.52p PS=6.4u PD=12.4u
M_d_930 _n_262 _n_219 BLn[0] VSS NMOS_mst L=1u W=3.4u AS=9.52p AD=5.1p PS=12.4u PD=6.4u
M_d_931 VSS _n_307 _n_262 VSS NMOS_mst L=1u W=3.4u AS=5.1p AD=5.1p PS=6.4u PD=6.4u
M_d_932 _n_307 _n_262 VSS VSS NMOS_mst L=1u W=3.4u AS=5.1p AD=5.1p PS=6.4u PD=6.4u
M_d_933 BLp[0] _n_219 _n_307 VSS NMOS_mst L=1u W=3.4u AS=5.1p AD=9.52p PS=6.4u PD=12.4u
M_d_934 _n_263 _n_220 BLn[0] VSS NMOS_mst L=1u W=3.4u AS=9.52p AD=5.1p PS=12.4u PD=6.4u
M_d_935 VSS _n_287 _n_263 VSS NMOS_mst L=1u W=3.4u AS=5.1p AD=5.1p PS=6.4u PD=6.4u
M_d_936 _n_287 _n_263 VSS VSS NMOS_mst L=1u W=3.4u AS=5.1p AD=5.1p PS=6.4u PD=6.4u
M_d_937 BLp[0] _n_220 _n_287 VSS NMOS_mst L=1u W=3.4u AS=5.1p AD=9.52p PS=6.4u PD=12.4u
M_d_938 _n_264 _n_221 BLn[0] VSS NMOS_mst L=1u W=3.4u AS=9.52p AD=5.1p PS=12.4u PD=6.4u
M_d_939 VSS _n_308 _n_264 VSS NMOS_mst L=1u W=3.4u AS=5.1p AD=5.1p PS=6.4u PD=6.4u
M_d_940 _n_308 _n_264 VSS VSS NMOS_mst L=1u W=3.4u AS=5.1p AD=5.1p PS=6.4u PD=6.4u
M_d_941 BLp[0] _n_221 _n_308 VSS NMOS_mst L=1u W=3.4u AS=5.1p AD=9.52p PS=6.4u PD=12.4u
M_d_942 _n_265 _n_222 BLn[0] VSS NMOS_mst L=1u W=3.4u AS=9.52p AD=5.1p PS=12.4u PD=6.4u
M_d_943 VSS _n_288 _n_265 VSS NMOS_mst L=1u W=3.4u AS=5.1p AD=5.1p PS=6.4u PD=6.4u
M_d_944 _n_288 _n_265 VSS VSS NMOS_mst L=1u W=3.4u AS=5.1p AD=5.1p PS=6.4u PD=6.4u
M_d_945 BLp[0] _n_222 _n_288 VSS NMOS_mst L=1u W=3.4u AS=5.1p AD=9.52p PS=6.4u PD=12.4u
M_d_946 _n_266 _n_223 BLn[0] VSS NMOS_mst L=1u W=3.4u AS=9.52p AD=5.1p PS=12.4u PD=6.4u
M_d_947 VSS _n_309 _n_266 VSS NMOS_mst L=1u W=3.4u AS=5.1p AD=5.1p PS=6.4u PD=6.4u
M_d_948 _n_309 _n_266 VSS VSS NMOS_mst L=1u W=3.4u AS=5.1p AD=5.1p PS=6.4u PD=6.4u
M_d_949 BLp[0] _n_223 _n_309 VSS NMOS_mst L=1u W=3.4u AS=5.1p AD=9.52p PS=6.4u PD=12.4u
M_d_950 _n_267 _n_224 BLn[0] VSS NMOS_mst L=1u W=3.4u AS=9.52p AD=5.1p PS=12.4u PD=6.4u
M_d_951 VSS _n_289 _n_267 VSS NMOS_mst L=1u W=3.4u AS=5.1p AD=5.1p PS=6.4u PD=6.4u
M_d_952 _n_289 _n_267 VSS VSS NMOS_mst L=1u W=3.4u AS=5.1p AD=5.1p PS=6.4u PD=6.4u
M_d_953 BLp[0] _n_224 _n_289 VSS NMOS_mst L=1u W=3.4u AS=5.1p AD=9.52p PS=6.4u PD=12.4u
M_d_954 _n_268 _n_225 BLn[0] VSS NMOS_mst L=1u W=3.4u AS=9.52p AD=5.1p PS=12.4u PD=6.4u
M_d_955 VSS _n_310 _n_268 VSS NMOS_mst L=1u W=3.4u AS=5.1p AD=5.1p PS=6.4u PD=6.4u
M_d_956 _n_310 _n_268 VSS VSS NMOS_mst L=1u W=3.4u AS=5.1p AD=5.1p PS=6.4u PD=6.4u
M_d_957 BLp[0] _n_225 _n_310 VSS NMOS_mst L=1u W=3.4u AS=5.1p AD=9.52p PS=6.4u PD=12.4u
M_d_958 _n_270 _n_227 BLn[0] VSS NMOS_mst L=1u W=3.4u AS=9.52p AD=5.1p PS=12.4u PD=6.4u
M_d_959 VSS _n_311 _n_270 VSS NMOS_mst L=1u W=3.4u AS=5.1p AD=5.1p PS=6.4u PD=6.4u
M_d_960 _n_311 _n_270 VSS VSS NMOS_mst L=1u W=3.4u AS=5.1p AD=5.1p PS=6.4u PD=6.4u
M_d_961 BLp[0] _n_227 _n_311 VSS NMOS_mst L=1u W=3.4u AS=5.1p AD=9.52p PS=6.4u PD=12.4u
M_d_962 _n_231 PRn VSS VSS NMOS_mst L=10u W=3.4u AS=9.52p AD=9.52p PS=12.4u PD=12.4u
M_d_963 _n_273 _n_272 VSS VSS NMOS_mst L=1u W=6.8u AS=14.62p AD=10.2p PS=18.8u PD=12.8u
M_d_965 DO[0] _n_313 VSS VSS NMOS_mst L=1u W=6.8u AS=10.2p AD=14.62p PS=12.8u PD=18.8u
M_d_967 VSS _n_275 _n_238 VSS NMOS_mst L=1u W=3.4u AS=9.52p AD=5.1p PS=12.4u PD=6.4u
M_d_968 _n_275 DIN[0] VSS VSS NMOS_mst L=1u W=3.4u AS=5.1p AD=9.52p PS=6.4u PD=12.4u
M_d_969 _n_293 WRp BLn[0] VSS NMOS_mst L=1u W=5.4u AS=15.12p AD=3.24p PS=16.4u PD=6.6u
M_d_970 VSS _n_238 _n_293 VSS NMOS_mst L=1u W=5.4u AS=3.24p AD=8.1p PS=6.6u PD=8.4u
M_d_971 _n_316 _n_275 VSS VSS NMOS_mst L=1u W=5.4u AS=8.1p AD=3.24p PS=8.4u PD=6.6u
M_d_972 BLp[0] WRp _n_316 VSS NMOS_mst L=1u W=5.4u AS=3.24p AD=15.12p PS=6.6u PD=16.4u
M_d_973 _n_243 _n_200 BLn[0] VSS NMOS_mst L=1u W=3.4u AS=9.52p AD=5.1p PS=12.4u PD=6.4u
M_d_974 VSS _n_277 _n_243 VSS NMOS_mst L=1u W=3.4u AS=5.1p AD=5.1p PS=6.4u PD=6.4u
M_d_975 _n_277 _n_243 VSS VSS NMOS_mst L=1u W=3.4u AS=5.1p AD=5.1p PS=6.4u PD=6.4u
M_d_976 BLp[0] _n_200 _n_277 VSS NMOS_mst L=1u W=3.4u AS=5.1p AD=9.52p PS=6.4u PD=12.4u
M_d_977 _n_251 _n_208 BLn[0] VSS NMOS_mst L=1u W=3.4u AS=9.52p AD=5.1p PS=12.4u PD=6.4u
M_d_978 VSS _n_281 _n_251 VSS NMOS_mst L=1u W=3.4u AS=5.1p AD=5.1p PS=6.4u PD=6.4u
M_d_979 _n_281 _n_251 VSS VSS NMOS_mst L=1u W=3.4u AS=5.1p AD=5.1p PS=6.4u PD=6.4u
M_d_980 BLp[0] _n_208 _n_281 VSS NMOS_mst L=1u W=3.4u AS=5.1p AD=9.52p PS=6.4u PD=12.4u
M_d_981 _n_253 _n_210 BLn[0] VSS NMOS_mst L=1u W=3.4u AS=9.52p AD=5.1p PS=12.4u PD=6.4u
M_d_982 VSS _n_282 _n_253 VSS NMOS_mst L=1u W=3.4u AS=5.1p AD=5.1p PS=6.4u PD=6.4u
M_d_983 _n_282 _n_253 VSS VSS NMOS_mst L=1u W=3.4u AS=5.1p AD=5.1p PS=6.4u PD=6.4u
M_d_984 BLp[0] _n_210 _n_282 VSS NMOS_mst L=1u W=3.4u AS=5.1p AD=9.52p PS=6.4u PD=12.4u
M_d_985 _n_254 _n_211 BLn[0] VSS NMOS_mst L=1u W=3.4u AS=9.52p AD=5.1p PS=12.4u PD=6.4u
M_d_986 VSS _n_303 _n_254 VSS NMOS_mst L=1u W=3.4u AS=5.1p AD=5.1p PS=6.4u PD=6.4u
M_d_987 _n_303 _n_254 VSS VSS NMOS_mst L=1u W=3.4u AS=5.1p AD=5.1p PS=6.4u PD=6.4u
M_d_988 BLp[0] _n_211 _n_303 VSS NMOS_mst L=1u W=3.4u AS=5.1p AD=9.52p PS=6.4u PD=12.4u
M_d_989 _n_256 _n_213 BLn[0] VSS NMOS_mst L=1u W=3.4u AS=9.52p AD=5.1p PS=12.4u PD=6.4u
M_d_990 VSS _n_304 _n_256 VSS NMOS_mst L=1u W=3.4u AS=5.1p AD=5.1p PS=6.4u PD=6.4u
M_d_991 _n_304 _n_256 VSS VSS NMOS_mst L=1u W=3.4u AS=5.1p AD=5.1p PS=6.4u PD=6.4u
M_d_992 BLp[0] _n_213 _n_304 VSS NMOS_mst L=1u W=3.4u AS=5.1p AD=9.52p PS=6.4u PD=12.4u
M_d_993 _n_259 _n_216 BLn[0] VSS NMOS_mst L=1u W=3.4u AS=9.52p AD=5.1p PS=12.4u PD=6.4u
M_d_994 VSS _n_285 _n_259 VSS NMOS_mst L=1u W=3.4u AS=5.1p AD=5.1p PS=6.4u PD=6.4u
M_d_995 _n_285 _n_259 VSS VSS NMOS_mst L=1u W=3.4u AS=5.1p AD=5.1p PS=6.4u PD=6.4u
M_d_996 BLp[0] _n_216 _n_285 VSS NMOS_mst L=1u W=3.4u AS=5.1p AD=9.52p PS=6.4u PD=12.4u
M_d_997 _n_269 _n_226 BLn[0] VSS NMOS_mst L=1u W=3.4u AS=9.52p AD=5.1p PS=12.4u PD=6.4u
M_d_998 VSS _n_290 _n_269 VSS NMOS_mst L=1u W=3.4u AS=5.1p AD=5.1p PS=6.4u PD=6.4u
M_d_999 _n_290 _n_269 VSS VSS NMOS_mst L=1u W=3.4u AS=5.1p AD=5.1p PS=6.4u PD=6.4u
M_d_1000 BLp[0] _n_226 _n_290 VSS NMOS_mst L=1u W=3.4u AS=5.1p AD=9.52p PS=6.4u PD=12.4u
M_d_1001 _n_271 _n_228 BLn[0] VSS NMOS_mst L=1u W=3.4u AS=9.52p AD=5.1p PS=12.4u PD=6.4u
M_d_1002 VSS _n_291 _n_271 VSS NMOS_mst L=1u W=3.4u AS=5.1p AD=5.1p PS=6.4u PD=6.4u
M_d_1003 _n_291 _n_271 VSS VSS NMOS_mst L=1u W=3.4u AS=5.1p AD=5.1p PS=6.4u PD=6.4u
M_d_1004 BLp[0] _n_228 _n_291 VSS NMOS_mst L=1u W=3.4u AS=5.1p AD=9.52p PS=6.4u PD=12.4u
M_d_1005 _n_312 LATp VSS VSS NMOS_mst L=1u W=10.8u AS=23.22p AD=23.22p PS=24.8u PD=24.8u
M_d_1007 _n_294 BLn[0] _n_272 VSS NMOS_mst L=1u W=5.4u AS=15.075p AD=3.24p PS=16.224u PD=6.6u
M_d_1008 _n_312 _n_313 _n_294 VSS NMOS_mst L=1u W=5.4u AS=3.24p AD=8.1p PS=6.6u PD=8.4u
M_d_1009 _n_317 _n_272 _n_312 VSS NMOS_mst L=1u W=5.4u AS=8.1p AD=3.24p PS=8.4u PD=6.6u
M_d_1010 _n_313 BLp[0] _n_317 VSS NMOS_mst L=1u W=5.4u AS=3.24p AD=15.075p PS=6.6u PD=16.224u
M_d_1011 _n_312 _n_313 _n_272 VSS NMOS_mst L=1u W=3.4u AS=9.52p AD=5.1p PS=12.4u PD=6.4u
M_d_1012 _n_313 _n_272 _n_312 VSS NMOS_mst L=1u W=3.4u AS=5.1p AD=9.52p PS=6.4u PD=12.4u
M_d_1013 _n_320 _n_197 BLn[1] VSS NMOS_mst L=1u W=3.4u AS=9.52p AD=5.1p PS=12.4u PD=6.4u
M_d_1014 VSS _n_376 _n_320 VSS NMOS_mst L=1u W=3.4u AS=5.1p AD=5.1p PS=6.4u PD=6.4u
M_d_1015 _n_376 _n_320 VSS VSS NMOS_mst L=1u W=3.4u AS=5.1p AD=5.1p PS=6.4u PD=6.4u
M_d_1016 BLp[1] _n_197 _n_376 VSS NMOS_mst L=1u W=3.4u AS=5.1p AD=9.52p PS=6.4u PD=12.4u
M_d_1017 _n_321 _n_198 BLn[1] VSS NMOS_mst L=1u W=3.4u AS=9.52p AD=5.1p PS=12.4u PD=6.4u
M_d_1018 VSS _n_356 _n_321 VSS NMOS_mst L=1u W=3.4u AS=5.1p AD=5.1p PS=6.4u PD=6.4u
M_d_1019 _n_356 _n_321 VSS VSS NMOS_mst L=1u W=3.4u AS=5.1p AD=5.1p PS=6.4u PD=6.4u
M_d_1020 BLp[1] _n_198 _n_356 VSS NMOS_mst L=1u W=3.4u AS=5.1p AD=9.52p PS=6.4u PD=12.4u
M_d_1021 _n_322 _n_199 BLn[1] VSS NMOS_mst L=1u W=3.4u AS=9.52p AD=5.1p PS=12.4u PD=6.4u
M_d_1022 VSS _n_377 _n_322 VSS NMOS_mst L=1u W=3.4u AS=5.1p AD=5.1p PS=6.4u PD=6.4u
M_d_1023 _n_377 _n_322 VSS VSS NMOS_mst L=1u W=3.4u AS=5.1p AD=5.1p PS=6.4u PD=6.4u
M_d_1024 BLp[1] _n_199 _n_377 VSS NMOS_mst L=1u W=3.4u AS=5.1p AD=9.52p PS=6.4u PD=12.4u
M_d_1025 _n_323 _n_200 BLn[1] VSS NMOS_mst L=1u W=3.4u AS=9.52p AD=5.1p PS=12.4u PD=6.4u
M_d_1026 VSS _n_357 _n_323 VSS NMOS_mst L=1u W=3.4u AS=5.1p AD=5.1p PS=6.4u PD=6.4u
M_d_1027 _n_357 _n_323 VSS VSS NMOS_mst L=1u W=3.4u AS=5.1p AD=5.1p PS=6.4u PD=6.4u
M_d_1028 BLp[1] _n_200 _n_357 VSS NMOS_mst L=1u W=3.4u AS=5.1p AD=9.52p PS=6.4u PD=12.4u
M_d_1029 _n_324 _n_201 BLn[1] VSS NMOS_mst L=1u W=3.4u AS=9.52p AD=5.1p PS=12.4u PD=6.4u
M_d_1030 VSS _n_378 _n_324 VSS NMOS_mst L=1u W=3.4u AS=5.1p AD=5.1p PS=6.4u PD=6.4u
M_d_1031 _n_378 _n_324 VSS VSS NMOS_mst L=1u W=3.4u AS=5.1p AD=5.1p PS=6.4u PD=6.4u
M_d_1032 BLp[1] _n_201 _n_378 VSS NMOS_mst L=1u W=3.4u AS=5.1p AD=9.52p PS=6.4u PD=12.4u
M_d_1033 _n_325 _n_202 BLn[1] VSS NMOS_mst L=1u W=3.4u AS=9.52p AD=5.1p PS=12.4u PD=6.4u
M_d_1034 VSS _n_358 _n_325 VSS NMOS_mst L=1u W=3.4u AS=5.1p AD=5.1p PS=6.4u PD=6.4u
M_d_1035 _n_358 _n_325 VSS VSS NMOS_mst L=1u W=3.4u AS=5.1p AD=5.1p PS=6.4u PD=6.4u
M_d_1036 BLp[1] _n_202 _n_358 VSS NMOS_mst L=1u W=3.4u AS=5.1p AD=9.52p PS=6.4u PD=12.4u
M_d_1037 _n_326 _n_203 BLn[1] VSS NMOS_mst L=1u W=3.4u AS=9.52p AD=5.1p PS=12.4u PD=6.4u
M_d_1038 VSS _n_379 _n_326 VSS NMOS_mst L=1u W=3.4u AS=5.1p AD=5.1p PS=6.4u PD=6.4u
M_d_1039 _n_379 _n_326 VSS VSS NMOS_mst L=1u W=3.4u AS=5.1p AD=5.1p PS=6.4u PD=6.4u
M_d_1040 BLp[1] _n_203 _n_379 VSS NMOS_mst L=1u W=3.4u AS=5.1p AD=9.52p PS=6.4u PD=12.4u
M_d_1041 _n_327 _n_204 BLn[1] VSS NMOS_mst L=1u W=3.4u AS=9.52p AD=5.1p PS=12.4u PD=6.4u
M_d_1042 VSS _n_359 _n_327 VSS NMOS_mst L=1u W=3.4u AS=5.1p AD=5.1p PS=6.4u PD=6.4u
M_d_1043 _n_359 _n_327 VSS VSS NMOS_mst L=1u W=3.4u AS=5.1p AD=5.1p PS=6.4u PD=6.4u
M_d_1044 BLp[1] _n_204 _n_359 VSS NMOS_mst L=1u W=3.4u AS=5.1p AD=9.52p PS=6.4u PD=12.4u
M_d_1045 _n_328 _n_205 BLn[1] VSS NMOS_mst L=1u W=3.4u AS=9.52p AD=5.1p PS=12.4u PD=6.4u
M_d_1046 VSS _n_380 _n_328 VSS NMOS_mst L=1u W=3.4u AS=5.1p AD=5.1p PS=6.4u PD=6.4u
M_d_1047 _n_380 _n_328 VSS VSS NMOS_mst L=1u W=3.4u AS=5.1p AD=5.1p PS=6.4u PD=6.4u
M_d_1048 BLp[1] _n_205 _n_380 VSS NMOS_mst L=1u W=3.4u AS=5.1p AD=9.52p PS=6.4u PD=12.4u
M_d_1049 _n_329 _n_206 BLn[1] VSS NMOS_mst L=1u W=3.4u AS=9.52p AD=5.1p PS=12.4u PD=6.4u
M_d_1050 VSS _n_360 _n_329 VSS NMOS_mst L=1u W=3.4u AS=5.1p AD=5.1p PS=6.4u PD=6.4u
M_d_1051 _n_360 _n_329 VSS VSS NMOS_mst L=1u W=3.4u AS=5.1p AD=5.1p PS=6.4u PD=6.4u
M_d_1052 BLp[1] _n_206 _n_360 VSS NMOS_mst L=1u W=3.4u AS=5.1p AD=9.52p PS=6.4u PD=12.4u
M_d_1053 _n_330 _n_207 BLn[1] VSS NMOS_mst L=1u W=3.4u AS=9.52p AD=5.1p PS=12.4u PD=6.4u
M_d_1054 VSS _n_381 _n_330 VSS NMOS_mst L=1u W=3.4u AS=5.1p AD=5.1p PS=6.4u PD=6.4u
M_d_1055 _n_381 _n_330 VSS VSS NMOS_mst L=1u W=3.4u AS=5.1p AD=5.1p PS=6.4u PD=6.4u
M_d_1056 BLp[1] _n_207 _n_381 VSS NMOS_mst L=1u W=3.4u AS=5.1p AD=9.52p PS=6.4u PD=12.4u
M_d_1057 _n_333 _n_210 BLn[1] VSS NMOS_mst L=1u W=3.4u AS=9.52p AD=5.1p PS=12.4u PD=6.4u
M_d_1058 VSS _n_362 _n_333 VSS NMOS_mst L=1u W=3.4u AS=5.1p AD=5.1p PS=6.4u PD=6.4u
M_d_1059 _n_362 _n_333 VSS VSS NMOS_mst L=1u W=3.4u AS=5.1p AD=5.1p PS=6.4u PD=6.4u
M_d_1060 BLp[1] _n_210 _n_362 VSS NMOS_mst L=1u W=3.4u AS=5.1p AD=9.52p PS=6.4u PD=12.4u
M_d_1061 _n_334 _n_211 BLn[1] VSS NMOS_mst L=1u W=3.4u AS=9.52p AD=5.1p PS=12.4u PD=6.4u
M_d_1062 VSS _n_383 _n_334 VSS NMOS_mst L=1u W=3.4u AS=5.1p AD=5.1p PS=6.4u PD=6.4u
M_d_1063 _n_383 _n_334 VSS VSS NMOS_mst L=1u W=3.4u AS=5.1p AD=5.1p PS=6.4u PD=6.4u
M_d_1064 BLp[1] _n_211 _n_383 VSS NMOS_mst L=1u W=3.4u AS=5.1p AD=9.52p PS=6.4u PD=12.4u
M_d_1065 _n_335 _n_212 BLn[1] VSS NMOS_mst L=1u W=3.4u AS=9.52p AD=5.1p PS=12.4u PD=6.4u
M_d_1066 VSS _n_363 _n_335 VSS NMOS_mst L=1u W=3.4u AS=5.1p AD=5.1p PS=6.4u PD=6.4u
M_d_1067 _n_363 _n_335 VSS VSS NMOS_mst L=1u W=3.4u AS=5.1p AD=5.1p PS=6.4u PD=6.4u
M_d_1068 BLp[1] _n_212 _n_363 VSS NMOS_mst L=1u W=3.4u AS=5.1p AD=9.52p PS=6.4u PD=12.4u
M_d_1069 _n_336 _n_213 BLn[1] VSS NMOS_mst L=1u W=3.4u AS=9.52p AD=5.1p PS=12.4u PD=6.4u
M_d_1070 VSS _n_384 _n_336 VSS NMOS_mst L=1u W=3.4u AS=5.1p AD=5.1p PS=6.4u PD=6.4u
M_d_1071 _n_384 _n_336 VSS VSS NMOS_mst L=1u W=3.4u AS=5.1p AD=5.1p PS=6.4u PD=6.4u
M_d_1072 BLp[1] _n_213 _n_384 VSS NMOS_mst L=1u W=3.4u AS=5.1p AD=9.52p PS=6.4u PD=12.4u
M_d_1073 _n_337 _n_214 BLn[1] VSS NMOS_mst L=1u W=3.4u AS=9.52p AD=5.1p PS=12.4u PD=6.4u
M_d_1074 VSS _n_364 _n_337 VSS NMOS_mst L=1u W=3.4u AS=5.1p AD=5.1p PS=6.4u PD=6.4u
M_d_1075 _n_364 _n_337 VSS VSS NMOS_mst L=1u W=3.4u AS=5.1p AD=5.1p PS=6.4u PD=6.4u
M_d_1076 BLp[1] _n_214 _n_364 VSS NMOS_mst L=1u W=3.4u AS=5.1p AD=9.52p PS=6.4u PD=12.4u
M_d_1077 _n_338 _n_215 BLn[1] VSS NMOS_mst L=1u W=3.4u AS=9.52p AD=5.1p PS=12.4u PD=6.4u
M_d_1078 VSS _n_385 _n_338 VSS NMOS_mst L=1u W=3.4u AS=5.1p AD=5.1p PS=6.4u PD=6.4u
M_d_1079 _n_385 _n_338 VSS VSS NMOS_mst L=1u W=3.4u AS=5.1p AD=5.1p PS=6.4u PD=6.4u
M_d_1080 BLp[1] _n_215 _n_385 VSS NMOS_mst L=1u W=3.4u AS=5.1p AD=9.52p PS=6.4u PD=12.4u
M_d_1081 _n_339 _n_216 BLn[1] VSS NMOS_mst L=1u W=3.4u AS=9.52p AD=5.1p PS=12.4u PD=6.4u
M_d_1082 VSS _n_365 _n_339 VSS NMOS_mst L=1u W=3.4u AS=5.1p AD=5.1p PS=6.4u PD=6.4u
M_d_1083 _n_365 _n_339 VSS VSS NMOS_mst L=1u W=3.4u AS=5.1p AD=5.1p PS=6.4u PD=6.4u
M_d_1084 BLp[1] _n_216 _n_365 VSS NMOS_mst L=1u W=3.4u AS=5.1p AD=9.52p PS=6.4u PD=12.4u
M_d_1085 _n_340 _n_217 BLn[1] VSS NMOS_mst L=1u W=3.4u AS=9.52p AD=5.1p PS=12.4u PD=6.4u
M_d_1086 VSS _n_386 _n_340 VSS NMOS_mst L=1u W=3.4u AS=5.1p AD=5.1p PS=6.4u PD=6.4u
M_d_1087 _n_386 _n_340 VSS VSS NMOS_mst L=1u W=3.4u AS=5.1p AD=5.1p PS=6.4u PD=6.4u
M_d_1088 BLp[1] _n_217 _n_386 VSS NMOS_mst L=1u W=3.4u AS=5.1p AD=9.52p PS=6.4u PD=12.4u
M_d_1089 _n_341 _n_218 BLn[1] VSS NMOS_mst L=1u W=3.4u AS=9.52p AD=5.1p PS=12.4u PD=6.4u
M_d_1090 VSS _n_366 _n_341 VSS NMOS_mst L=1u W=3.4u AS=5.1p AD=5.1p PS=6.4u PD=6.4u
M_d_1091 _n_366 _n_341 VSS VSS NMOS_mst L=1u W=3.4u AS=5.1p AD=5.1p PS=6.4u PD=6.4u
M_d_1092 BLp[1] _n_218 _n_366 VSS NMOS_mst L=1u W=3.4u AS=5.1p AD=9.52p PS=6.4u PD=12.4u
M_d_1093 _n_343 _n_220 BLn[1] VSS NMOS_mst L=1u W=3.4u AS=9.52p AD=5.1p PS=12.4u PD=6.4u
M_d_1094 VSS _n_367 _n_343 VSS NMOS_mst L=1u W=3.4u AS=5.1p AD=5.1p PS=6.4u PD=6.4u
M_d_1095 _n_367 _n_343 VSS VSS NMOS_mst L=1u W=3.4u AS=5.1p AD=5.1p PS=6.4u PD=6.4u
M_d_1096 BLp[1] _n_220 _n_367 VSS NMOS_mst L=1u W=3.4u AS=5.1p AD=9.52p PS=6.4u PD=12.4u
M_d_1097 _n_345 _n_222 BLn[1] VSS NMOS_mst L=1u W=3.4u AS=9.52p AD=5.1p PS=12.4u PD=6.4u
M_d_1098 VSS _n_368 _n_345 VSS NMOS_mst L=1u W=3.4u AS=5.1p AD=5.1p PS=6.4u PD=6.4u
M_d_1099 _n_368 _n_345 VSS VSS NMOS_mst L=1u W=3.4u AS=5.1p AD=5.1p PS=6.4u PD=6.4u
M_d_1100 BLp[1] _n_222 _n_368 VSS NMOS_mst L=1u W=3.4u AS=5.1p AD=9.52p PS=6.4u PD=12.4u
M_d_1101 _n_346 _n_223 BLn[1] VSS NMOS_mst L=1u W=3.4u AS=9.52p AD=5.1p PS=12.4u PD=6.4u
M_d_1102 VSS _n_389 _n_346 VSS NMOS_mst L=1u W=3.4u AS=5.1p AD=5.1p PS=6.4u PD=6.4u
M_d_1103 _n_389 _n_346 VSS VSS NMOS_mst L=1u W=3.4u AS=5.1p AD=5.1p PS=6.4u PD=6.4u
M_d_1104 BLp[1] _n_223 _n_389 VSS NMOS_mst L=1u W=3.4u AS=5.1p AD=9.52p PS=6.4u PD=12.4u
M_d_1105 _n_347 _n_224 BLn[1] VSS NMOS_mst L=1u W=3.4u AS=9.52p AD=5.1p PS=12.4u PD=6.4u
M_d_1106 VSS _n_369 _n_347 VSS NMOS_mst L=1u W=3.4u AS=5.1p AD=5.1p PS=6.4u PD=6.4u
M_d_1107 _n_369 _n_347 VSS VSS NMOS_mst L=1u W=3.4u AS=5.1p AD=5.1p PS=6.4u PD=6.4u
M_d_1108 BLp[1] _n_224 _n_369 VSS NMOS_mst L=1u W=3.4u AS=5.1p AD=9.52p PS=6.4u PD=12.4u
M_d_1109 _n_348 _n_225 BLn[1] VSS NMOS_mst L=1u W=3.4u AS=9.52p AD=5.1p PS=12.4u PD=6.4u
M_d_1110 VSS _n_390 _n_348 VSS NMOS_mst L=1u W=3.4u AS=5.1p AD=5.1p PS=6.4u PD=6.4u
M_d_1111 _n_390 _n_348 VSS VSS NMOS_mst L=1u W=3.4u AS=5.1p AD=5.1p PS=6.4u PD=6.4u
M_d_1112 BLp[1] _n_225 _n_390 VSS NMOS_mst L=1u W=3.4u AS=5.1p AD=9.52p PS=6.4u PD=12.4u
M_d_1113 _n_349 _n_226 BLn[1] VSS NMOS_mst L=1u W=3.4u AS=9.52p AD=5.1p PS=12.4u PD=6.4u
M_d_1114 VSS _n_370 _n_349 VSS NMOS_mst L=1u W=3.4u AS=5.1p AD=5.1p PS=6.4u PD=6.4u
M_d_1115 _n_370 _n_349 VSS VSS NMOS_mst L=1u W=3.4u AS=5.1p AD=5.1p PS=6.4u PD=6.4u
M_d_1116 BLp[1] _n_226 _n_370 VSS NMOS_mst L=1u W=3.4u AS=5.1p AD=9.52p PS=6.4u PD=12.4u
M_d_1117 _n_350 _n_227 BLn[1] VSS NMOS_mst L=1u W=3.4u AS=9.52p AD=5.1p PS=12.4u PD=6.4u
M_d_1118 VSS _n_391 _n_350 VSS NMOS_mst L=1u W=3.4u AS=5.1p AD=5.1p PS=6.4u PD=6.4u
M_d_1119 _n_391 _n_350 VSS VSS NMOS_mst L=1u W=3.4u AS=5.1p AD=5.1p PS=6.4u PD=6.4u
M_d_1120 BLp[1] _n_227 _n_391 VSS NMOS_mst L=1u W=3.4u AS=5.1p AD=9.52p PS=6.4u PD=12.4u
M_d_1121 _n_353 _n_352 VSS VSS NMOS_mst L=1u W=6.8u AS=14.62p AD=10.2p PS=18.8u PD=12.8u
M_d_1123 DO[1] _n_393 VSS VSS NMOS_mst L=1u W=6.8u AS=10.2p AD=14.62p PS=12.8u PD=18.8u
M_d_1125 VSS _n_355 _n_318 VSS NMOS_mst L=1u W=3.4u AS=9.52p AD=5.1p PS=12.4u PD=6.4u
M_d_1126 _n_355 DIN[1] VSS VSS NMOS_mst L=1u W=3.4u AS=5.1p AD=9.52p PS=6.4u PD=12.4u
M_d_1127 _n_373 WRp BLn[1] VSS NMOS_mst L=1u W=5.4u AS=15.12p AD=3.24p PS=16.4u PD=6.6u
M_d_1128 VSS _n_318 _n_373 VSS NMOS_mst L=1u W=5.4u AS=3.24p AD=8.1p PS=6.6u PD=8.4u
M_d_1129 _n_396 _n_355 VSS VSS NMOS_mst L=1u W=5.4u AS=8.1p AD=3.24p PS=8.4u PD=6.6u
M_d_1130 BLp[1] WRp _n_396 VSS NMOS_mst L=1u W=5.4u AS=3.24p AD=15.12p PS=6.6u PD=16.4u
M_d_1131 _n_331 _n_208 BLn[1] VSS NMOS_mst L=1u W=3.4u AS=9.52p AD=5.1p PS=12.4u PD=6.4u
M_d_1132 VSS _n_361 _n_331 VSS NMOS_mst L=1u W=3.4u AS=5.1p AD=5.1p PS=6.4u PD=6.4u
M_d_1133 _n_361 _n_331 VSS VSS NMOS_mst L=1u W=3.4u AS=5.1p AD=5.1p PS=6.4u PD=6.4u
M_d_1134 BLp[1] _n_208 _n_361 VSS NMOS_mst L=1u W=3.4u AS=5.1p AD=9.52p PS=6.4u PD=12.4u
M_d_1135 _n_332 _n_209 BLn[1] VSS NMOS_mst L=1u W=3.4u AS=9.52p AD=5.1p PS=12.4u PD=6.4u
M_d_1136 VSS _n_382 _n_332 VSS NMOS_mst L=1u W=3.4u AS=5.1p AD=5.1p PS=6.4u PD=6.4u
M_d_1137 _n_382 _n_332 VSS VSS NMOS_mst L=1u W=3.4u AS=5.1p AD=5.1p PS=6.4u PD=6.4u
M_d_1138 BLp[1] _n_209 _n_382 VSS NMOS_mst L=1u W=3.4u AS=5.1p AD=9.52p PS=6.4u PD=12.4u
M_d_1139 _n_342 _n_219 BLn[1] VSS NMOS_mst L=1u W=3.4u AS=9.52p AD=5.1p PS=12.4u PD=6.4u
M_d_1140 VSS _n_387 _n_342 VSS NMOS_mst L=1u W=3.4u AS=5.1p AD=5.1p PS=6.4u PD=6.4u
M_d_1141 _n_387 _n_342 VSS VSS NMOS_mst L=1u W=3.4u AS=5.1p AD=5.1p PS=6.4u PD=6.4u
M_d_1142 BLp[1] _n_219 _n_387 VSS NMOS_mst L=1u W=3.4u AS=5.1p AD=9.52p PS=6.4u PD=12.4u
M_d_1143 _n_344 _n_221 BLn[1] VSS NMOS_mst L=1u W=3.4u AS=9.52p AD=5.1p PS=12.4u PD=6.4u
M_d_1144 VSS _n_388 _n_344 VSS NMOS_mst L=1u W=3.4u AS=5.1p AD=5.1p PS=6.4u PD=6.4u
M_d_1145 _n_388 _n_344 VSS VSS NMOS_mst L=1u W=3.4u AS=5.1p AD=5.1p PS=6.4u PD=6.4u
M_d_1146 BLp[1] _n_221 _n_388 VSS NMOS_mst L=1u W=3.4u AS=5.1p AD=9.52p PS=6.4u PD=12.4u
M_d_1147 _n_351 _n_228 BLn[1] VSS NMOS_mst L=1u W=3.4u AS=9.52p AD=5.1p PS=12.4u PD=6.4u
M_d_1148 VSS _n_371 _n_351 VSS NMOS_mst L=1u W=3.4u AS=5.1p AD=5.1p PS=6.4u PD=6.4u
M_d_1149 _n_371 _n_351 VSS VSS NMOS_mst L=1u W=3.4u AS=5.1p AD=5.1p PS=6.4u PD=6.4u
M_d_1150 BLp[1] _n_228 _n_371 VSS NMOS_mst L=1u W=3.4u AS=5.1p AD=9.52p PS=6.4u PD=12.4u
M_d_1151 _n_392 LATp VSS VSS NMOS_mst L=1u W=10.8u AS=23.22p AD=23.22p PS=24.8u PD=24.8u
M_d_1153 _n_374 BLn[1] _n_352 VSS NMOS_mst L=1u W=5.4u AS=15.075p AD=3.24p PS=16.224u PD=6.6u
M_d_1154 _n_392 _n_393 _n_374 VSS NMOS_mst L=1u W=5.4u AS=3.24p AD=8.1p PS=6.6u PD=8.4u
M_d_1155 _n_397 _n_352 _n_392 VSS NMOS_mst L=1u W=5.4u AS=8.1p AD=3.24p PS=8.4u PD=6.6u
M_d_1156 _n_393 BLp[1] _n_397 VSS NMOS_mst L=1u W=5.4u AS=3.24p AD=15.075p PS=6.6u PD=16.224u
M_d_1157 _n_392 _n_393 _n_352 VSS NMOS_mst L=1u W=3.4u AS=9.52p AD=5.1p PS=12.4u PD=6.4u
M_d_1158 _n_393 _n_352 _n_392 VSS NMOS_mst L=1u W=3.4u AS=5.1p AD=9.52p PS=6.4u PD=12.4u
M_d_1159 _n_400 _n_197 BLn[2] VSS NMOS_mst L=1u W=3.4u AS=9.52p AD=5.1p PS=12.4u PD=6.4u
M_d_1160 VSS _n_456 _n_400 VSS NMOS_mst L=1u W=3.4u AS=5.1p AD=5.1p PS=6.4u PD=6.4u
M_d_1161 _n_456 _n_400 VSS VSS NMOS_mst L=1u W=3.4u AS=5.1p AD=5.1p PS=6.4u PD=6.4u
M_d_1162 BLp[2] _n_197 _n_456 VSS NMOS_mst L=1u W=3.4u AS=5.1p AD=9.52p PS=6.4u PD=12.4u
M_d_1163 _n_401 _n_198 BLn[2] VSS NMOS_mst L=1u W=3.4u AS=9.52p AD=5.1p PS=12.4u PD=6.4u
M_d_1164 VSS _n_436 _n_401 VSS NMOS_mst L=1u W=3.4u AS=5.1p AD=5.1p PS=6.4u PD=6.4u
M_d_1165 _n_436 _n_401 VSS VSS NMOS_mst L=1u W=3.4u AS=5.1p AD=5.1p PS=6.4u PD=6.4u
M_d_1166 BLp[2] _n_198 _n_436 VSS NMOS_mst L=1u W=3.4u AS=5.1p AD=9.52p PS=6.4u PD=12.4u
M_d_1167 _n_402 _n_199 BLn[2] VSS NMOS_mst L=1u W=3.4u AS=9.52p AD=5.1p PS=12.4u PD=6.4u
M_d_1168 VSS _n_457 _n_402 VSS NMOS_mst L=1u W=3.4u AS=5.1p AD=5.1p PS=6.4u PD=6.4u
M_d_1169 _n_457 _n_402 VSS VSS NMOS_mst L=1u W=3.4u AS=5.1p AD=5.1p PS=6.4u PD=6.4u
M_d_1170 BLp[2] _n_199 _n_457 VSS NMOS_mst L=1u W=3.4u AS=5.1p AD=9.52p PS=6.4u PD=12.4u
M_d_1171 _n_403 _n_200 BLn[2] VSS NMOS_mst L=1u W=3.4u AS=9.52p AD=5.1p PS=12.4u PD=6.4u
M_d_1172 VSS _n_437 _n_403 VSS NMOS_mst L=1u W=3.4u AS=5.1p AD=5.1p PS=6.4u PD=6.4u
M_d_1173 _n_437 _n_403 VSS VSS NMOS_mst L=1u W=3.4u AS=5.1p AD=5.1p PS=6.4u PD=6.4u
M_d_1174 BLp[2] _n_200 _n_437 VSS NMOS_mst L=1u W=3.4u AS=5.1p AD=9.52p PS=6.4u PD=12.4u
M_d_1175 _n_404 _n_201 BLn[2] VSS NMOS_mst L=1u W=3.4u AS=9.52p AD=5.1p PS=12.4u PD=6.4u
M_d_1176 VSS _n_458 _n_404 VSS NMOS_mst L=1u W=3.4u AS=5.1p AD=5.1p PS=6.4u PD=6.4u
M_d_1177 _n_458 _n_404 VSS VSS NMOS_mst L=1u W=3.4u AS=5.1p AD=5.1p PS=6.4u PD=6.4u
M_d_1178 BLp[2] _n_201 _n_458 VSS NMOS_mst L=1u W=3.4u AS=5.1p AD=9.52p PS=6.4u PD=12.4u
M_d_1179 _n_405 _n_202 BLn[2] VSS NMOS_mst L=1u W=3.4u AS=9.52p AD=5.1p PS=12.4u PD=6.4u
M_d_1180 VSS _n_438 _n_405 VSS NMOS_mst L=1u W=3.4u AS=5.1p AD=5.1p PS=6.4u PD=6.4u
M_d_1181 _n_438 _n_405 VSS VSS NMOS_mst L=1u W=3.4u AS=5.1p AD=5.1p PS=6.4u PD=6.4u
M_d_1182 BLp[2] _n_202 _n_438 VSS NMOS_mst L=1u W=3.4u AS=5.1p AD=9.52p PS=6.4u PD=12.4u
M_d_1183 _n_407 _n_204 BLn[2] VSS NMOS_mst L=1u W=3.4u AS=9.52p AD=5.1p PS=12.4u PD=6.4u
M_d_1184 VSS _n_439 _n_407 VSS NMOS_mst L=1u W=3.4u AS=5.1p AD=5.1p PS=6.4u PD=6.4u
M_d_1185 _n_439 _n_407 VSS VSS NMOS_mst L=1u W=3.4u AS=5.1p AD=5.1p PS=6.4u PD=6.4u
M_d_1186 BLp[2] _n_204 _n_439 VSS NMOS_mst L=1u W=3.4u AS=5.1p AD=9.52p PS=6.4u PD=12.4u
M_d_1187 _n_408 _n_205 BLn[2] VSS NMOS_mst L=1u W=3.4u AS=9.52p AD=5.1p PS=12.4u PD=6.4u
M_d_1188 VSS _n_460 _n_408 VSS NMOS_mst L=1u W=3.4u AS=5.1p AD=5.1p PS=6.4u PD=6.4u
M_d_1189 _n_460 _n_408 VSS VSS NMOS_mst L=1u W=3.4u AS=5.1p AD=5.1p PS=6.4u PD=6.4u
M_d_1190 BLp[2] _n_205 _n_460 VSS NMOS_mst L=1u W=3.4u AS=5.1p AD=9.52p PS=6.4u PD=12.4u
M_d_1191 _n_409 _n_206 BLn[2] VSS NMOS_mst L=1u W=3.4u AS=9.52p AD=5.1p PS=12.4u PD=6.4u
M_d_1192 VSS _n_440 _n_409 VSS NMOS_mst L=1u W=3.4u AS=5.1p AD=5.1p PS=6.4u PD=6.4u
M_d_1193 _n_440 _n_409 VSS VSS NMOS_mst L=1u W=3.4u AS=5.1p AD=5.1p PS=6.4u PD=6.4u
M_d_1194 BLp[2] _n_206 _n_440 VSS NMOS_mst L=1u W=3.4u AS=5.1p AD=9.52p PS=6.4u PD=12.4u
M_d_1195 _n_410 _n_207 BLn[2] VSS NMOS_mst L=1u W=3.4u AS=9.52p AD=5.1p PS=12.4u PD=6.4u
M_d_1196 VSS _n_461 _n_410 VSS NMOS_mst L=1u W=3.4u AS=5.1p AD=5.1p PS=6.4u PD=6.4u
M_d_1197 _n_461 _n_410 VSS VSS NMOS_mst L=1u W=3.4u AS=5.1p AD=5.1p PS=6.4u PD=6.4u
M_d_1198 BLp[2] _n_207 _n_461 VSS NMOS_mst L=1u W=3.4u AS=5.1p AD=9.52p PS=6.4u PD=12.4u
M_d_1199 _n_411 _n_208 BLn[2] VSS NMOS_mst L=1u W=3.4u AS=9.52p AD=5.1p PS=12.4u PD=6.4u
M_d_1200 VSS _n_441 _n_411 VSS NMOS_mst L=1u W=3.4u AS=5.1p AD=5.1p PS=6.4u PD=6.4u
M_d_1201 _n_441 _n_411 VSS VSS NMOS_mst L=1u W=3.4u AS=5.1p AD=5.1p PS=6.4u PD=6.4u
M_d_1202 BLp[2] _n_208 _n_441 VSS NMOS_mst L=1u W=3.4u AS=5.1p AD=9.52p PS=6.4u PD=12.4u
M_d_1203 _n_412 _n_209 BLn[2] VSS NMOS_mst L=1u W=3.4u AS=9.52p AD=5.1p PS=12.4u PD=6.4u
M_d_1204 VSS _n_462 _n_412 VSS NMOS_mst L=1u W=3.4u AS=5.1p AD=5.1p PS=6.4u PD=6.4u
M_d_1205 _n_462 _n_412 VSS VSS NMOS_mst L=1u W=3.4u AS=5.1p AD=5.1p PS=6.4u PD=6.4u
M_d_1206 BLp[2] _n_209 _n_462 VSS NMOS_mst L=1u W=3.4u AS=5.1p AD=9.52p PS=6.4u PD=12.4u
M_d_1207 _n_413 _n_210 BLn[2] VSS NMOS_mst L=1u W=3.4u AS=9.52p AD=5.1p PS=12.4u PD=6.4u
M_d_1208 VSS _n_442 _n_413 VSS NMOS_mst L=1u W=3.4u AS=5.1p AD=5.1p PS=6.4u PD=6.4u
M_d_1209 _n_442 _n_413 VSS VSS NMOS_mst L=1u W=3.4u AS=5.1p AD=5.1p PS=6.4u PD=6.4u
M_d_1210 BLp[2] _n_210 _n_442 VSS NMOS_mst L=1u W=3.4u AS=5.1p AD=9.52p PS=6.4u PD=12.4u
M_d_1211 _n_414 _n_211 BLn[2] VSS NMOS_mst L=1u W=3.4u AS=9.52p AD=5.1p PS=12.4u PD=6.4u
M_d_1212 VSS _n_463 _n_414 VSS NMOS_mst L=1u W=3.4u AS=5.1p AD=5.1p PS=6.4u PD=6.4u
M_d_1213 _n_463 _n_414 VSS VSS NMOS_mst L=1u W=3.4u AS=5.1p AD=5.1p PS=6.4u PD=6.4u
M_d_1214 BLp[2] _n_211 _n_463 VSS NMOS_mst L=1u W=3.4u AS=5.1p AD=9.52p PS=6.4u PD=12.4u
M_d_1215 _n_416 _n_213 BLn[2] VSS NMOS_mst L=1u W=3.4u AS=9.52p AD=5.1p PS=12.4u PD=6.4u
M_d_1216 VSS _n_464 _n_416 VSS NMOS_mst L=1u W=3.4u AS=5.1p AD=5.1p PS=6.4u PD=6.4u
M_d_1217 _n_464 _n_416 VSS VSS NMOS_mst L=1u W=3.4u AS=5.1p AD=5.1p PS=6.4u PD=6.4u
M_d_1218 BLp[2] _n_213 _n_464 VSS NMOS_mst L=1u W=3.4u AS=5.1p AD=9.52p PS=6.4u PD=12.4u
M_d_1219 _n_418 _n_215 BLn[2] VSS NMOS_mst L=1u W=3.4u AS=9.52p AD=5.1p PS=12.4u PD=6.4u
M_d_1220 VSS _n_465 _n_418 VSS NMOS_mst L=1u W=3.4u AS=5.1p AD=5.1p PS=6.4u PD=6.4u
M_d_1221 _n_465 _n_418 VSS VSS NMOS_mst L=1u W=3.4u AS=5.1p AD=5.1p PS=6.4u PD=6.4u
M_d_1222 BLp[2] _n_215 _n_465 VSS NMOS_mst L=1u W=3.4u AS=5.1p AD=9.52p PS=6.4u PD=12.4u
M_d_1223 _n_419 _n_216 BLn[2] VSS NMOS_mst L=1u W=3.4u AS=9.52p AD=5.1p PS=12.4u PD=6.4u
M_d_1224 VSS _n_445 _n_419 VSS NMOS_mst L=1u W=3.4u AS=5.1p AD=5.1p PS=6.4u PD=6.4u
M_d_1225 _n_445 _n_419 VSS VSS NMOS_mst L=1u W=3.4u AS=5.1p AD=5.1p PS=6.4u PD=6.4u
M_d_1226 BLp[2] _n_216 _n_445 VSS NMOS_mst L=1u W=3.4u AS=5.1p AD=9.52p PS=6.4u PD=12.4u
M_d_1227 _n_420 _n_217 BLn[2] VSS NMOS_mst L=1u W=3.4u AS=9.52p AD=5.1p PS=12.4u PD=6.4u
M_d_1228 VSS _n_466 _n_420 VSS NMOS_mst L=1u W=3.4u AS=5.1p AD=5.1p PS=6.4u PD=6.4u
M_d_1229 _n_466 _n_420 VSS VSS NMOS_mst L=1u W=3.4u AS=5.1p AD=5.1p PS=6.4u PD=6.4u
M_d_1230 BLp[2] _n_217 _n_466 VSS NMOS_mst L=1u W=3.4u AS=5.1p AD=9.52p PS=6.4u PD=12.4u
M_d_1231 _n_421 _n_218 BLn[2] VSS NMOS_mst L=1u W=3.4u AS=9.52p AD=5.1p PS=12.4u PD=6.4u
M_d_1232 VSS _n_446 _n_421 VSS NMOS_mst L=1u W=3.4u AS=5.1p AD=5.1p PS=6.4u PD=6.4u
M_d_1233 _n_446 _n_421 VSS VSS NMOS_mst L=1u W=3.4u AS=5.1p AD=5.1p PS=6.4u PD=6.4u
M_d_1234 BLp[2] _n_218 _n_446 VSS NMOS_mst L=1u W=3.4u AS=5.1p AD=9.52p PS=6.4u PD=12.4u
M_d_1235 _n_424 _n_221 BLn[2] VSS NMOS_mst L=1u W=3.4u AS=9.52p AD=5.1p PS=12.4u PD=6.4u
M_d_1236 VSS _n_468 _n_424 VSS NMOS_mst L=1u W=3.4u AS=5.1p AD=5.1p PS=6.4u PD=6.4u
M_d_1237 _n_468 _n_424 VSS VSS NMOS_mst L=1u W=3.4u AS=5.1p AD=5.1p PS=6.4u PD=6.4u
M_d_1238 BLp[2] _n_221 _n_468 VSS NMOS_mst L=1u W=3.4u AS=5.1p AD=9.52p PS=6.4u PD=12.4u
M_d_1239 _n_425 _n_222 BLn[2] VSS NMOS_mst L=1u W=3.4u AS=9.52p AD=5.1p PS=12.4u PD=6.4u
M_d_1240 VSS _n_448 _n_425 VSS NMOS_mst L=1u W=3.4u AS=5.1p AD=5.1p PS=6.4u PD=6.4u
M_d_1241 _n_448 _n_425 VSS VSS NMOS_mst L=1u W=3.4u AS=5.1p AD=5.1p PS=6.4u PD=6.4u
M_d_1242 BLp[2] _n_222 _n_448 VSS NMOS_mst L=1u W=3.4u AS=5.1p AD=9.52p PS=6.4u PD=12.4u
M_d_1243 _n_426 _n_223 BLn[2] VSS NMOS_mst L=1u W=3.4u AS=9.52p AD=5.1p PS=12.4u PD=6.4u
M_d_1244 VSS _n_469 _n_426 VSS NMOS_mst L=1u W=3.4u AS=5.1p AD=5.1p PS=6.4u PD=6.4u
M_d_1245 _n_469 _n_426 VSS VSS NMOS_mst L=1u W=3.4u AS=5.1p AD=5.1p PS=6.4u PD=6.4u
M_d_1246 BLp[2] _n_223 _n_469 VSS NMOS_mst L=1u W=3.4u AS=5.1p AD=9.52p PS=6.4u PD=12.4u
M_d_1247 _n_427 _n_224 BLn[2] VSS NMOS_mst L=1u W=3.4u AS=9.52p AD=5.1p PS=12.4u PD=6.4u
M_d_1248 VSS _n_449 _n_427 VSS NMOS_mst L=1u W=3.4u AS=5.1p AD=5.1p PS=6.4u PD=6.4u
M_d_1249 _n_449 _n_427 VSS VSS NMOS_mst L=1u W=3.4u AS=5.1p AD=5.1p PS=6.4u PD=6.4u
M_d_1250 BLp[2] _n_224 _n_449 VSS NMOS_mst L=1u W=3.4u AS=5.1p AD=9.52p PS=6.4u PD=12.4u
M_d_1251 _n_428 _n_225 BLn[2] VSS NMOS_mst L=1u W=3.4u AS=9.52p AD=5.1p PS=12.4u PD=6.4u
M_d_1252 VSS _n_470 _n_428 VSS NMOS_mst L=1u W=3.4u AS=5.1p AD=5.1p PS=6.4u PD=6.4u
M_d_1253 _n_470 _n_428 VSS VSS NMOS_mst L=1u W=3.4u AS=5.1p AD=5.1p PS=6.4u PD=6.4u
M_d_1254 BLp[2] _n_225 _n_470 VSS NMOS_mst L=1u W=3.4u AS=5.1p AD=9.52p PS=6.4u PD=12.4u
M_d_1255 _n_429 _n_226 BLn[2] VSS NMOS_mst L=1u W=3.4u AS=9.52p AD=5.1p PS=12.4u PD=6.4u
M_d_1256 VSS _n_450 _n_429 VSS NMOS_mst L=1u W=3.4u AS=5.1p AD=5.1p PS=6.4u PD=6.4u
M_d_1257 _n_450 _n_429 VSS VSS NMOS_mst L=1u W=3.4u AS=5.1p AD=5.1p PS=6.4u PD=6.4u
M_d_1258 BLp[2] _n_226 _n_450 VSS NMOS_mst L=1u W=3.4u AS=5.1p AD=9.52p PS=6.4u PD=12.4u
M_d_1259 _n_430 _n_227 BLn[2] VSS NMOS_mst L=1u W=3.4u AS=9.52p AD=5.1p PS=12.4u PD=6.4u
M_d_1260 VSS _n_471 _n_430 VSS NMOS_mst L=1u W=3.4u AS=5.1p AD=5.1p PS=6.4u PD=6.4u
M_d_1261 _n_471 _n_430 VSS VSS NMOS_mst L=1u W=3.4u AS=5.1p AD=5.1p PS=6.4u PD=6.4u
M_d_1262 BLp[2] _n_227 _n_471 VSS NMOS_mst L=1u W=3.4u AS=5.1p AD=9.52p PS=6.4u PD=12.4u
M_d_1263 _n_431 _n_228 BLn[2] VSS NMOS_mst L=1u W=3.4u AS=9.52p AD=5.1p PS=12.4u PD=6.4u
M_d_1264 VSS _n_451 _n_431 VSS NMOS_mst L=1u W=3.4u AS=5.1p AD=5.1p PS=6.4u PD=6.4u
M_d_1265 _n_451 _n_431 VSS VSS NMOS_mst L=1u W=3.4u AS=5.1p AD=5.1p PS=6.4u PD=6.4u
M_d_1266 BLp[2] _n_228 _n_451 VSS NMOS_mst L=1u W=3.4u AS=5.1p AD=9.52p PS=6.4u PD=12.4u
M_d_1267 _n_433 _n_432 VSS VSS NMOS_mst L=1u W=6.8u AS=14.62p AD=10.2p PS=18.8u PD=12.8u
M_d_1269 DO[2] _n_473 VSS VSS NMOS_mst L=1u W=6.8u AS=10.2p AD=14.62p PS=12.8u PD=18.8u
M_d_1271 _n_453 WRp BLn[2] VSS NMOS_mst L=1u W=5.4u AS=15.12p AD=3.24p PS=16.4u PD=6.6u
M_d_1272 VSS _n_398 _n_453 VSS NMOS_mst L=1u W=5.4u AS=3.24p AD=8.1p PS=6.6u PD=8.4u
M_d_1273 _n_476 _n_435 VSS VSS NMOS_mst L=1u W=5.4u AS=8.1p AD=3.24p PS=8.4u PD=6.6u
M_d_1274 BLp[2] WRp _n_476 VSS NMOS_mst L=1u W=5.4u AS=3.24p AD=15.12p PS=6.6u PD=16.4u
M_d_1275 _n_406 _n_203 BLn[2] VSS NMOS_mst L=1u W=3.4u AS=9.52p AD=5.1p PS=12.4u PD=6.4u
M_d_1276 VSS _n_459 _n_406 VSS NMOS_mst L=1u W=3.4u AS=5.1p AD=5.1p PS=6.4u PD=6.4u
M_d_1277 _n_459 _n_406 VSS VSS NMOS_mst L=1u W=3.4u AS=5.1p AD=5.1p PS=6.4u PD=6.4u
M_d_1278 BLp[2] _n_203 _n_459 VSS NMOS_mst L=1u W=3.4u AS=5.1p AD=9.52p PS=6.4u PD=12.4u
M_d_1279 _n_415 _n_212 BLn[2] VSS NMOS_mst L=1u W=3.4u AS=9.52p AD=5.1p PS=12.4u PD=6.4u
M_d_1280 VSS _n_443 _n_415 VSS NMOS_mst L=1u W=3.4u AS=5.1p AD=5.1p PS=6.4u PD=6.4u
M_d_1281 _n_443 _n_415 VSS VSS NMOS_mst L=1u W=3.4u AS=5.1p AD=5.1p PS=6.4u PD=6.4u
M_d_1282 BLp[2] _n_212 _n_443 VSS NMOS_mst L=1u W=3.4u AS=5.1p AD=9.52p PS=6.4u PD=12.4u
M_d_1283 _n_417 _n_214 BLn[2] VSS NMOS_mst L=1u W=3.4u AS=9.52p AD=5.1p PS=12.4u PD=6.4u
M_d_1284 VSS _n_444 _n_417 VSS NMOS_mst L=1u W=3.4u AS=5.1p AD=5.1p PS=6.4u PD=6.4u
M_d_1285 _n_444 _n_417 VSS VSS NMOS_mst L=1u W=3.4u AS=5.1p AD=5.1p PS=6.4u PD=6.4u
M_d_1286 BLp[2] _n_214 _n_444 VSS NMOS_mst L=1u W=3.4u AS=5.1p AD=9.52p PS=6.4u PD=12.4u
M_d_1287 _n_422 _n_219 BLn[2] VSS NMOS_mst L=1u W=3.4u AS=9.52p AD=5.1p PS=12.4u PD=6.4u
M_d_1288 VSS _n_467 _n_422 VSS NMOS_mst L=1u W=3.4u AS=5.1p AD=5.1p PS=6.4u PD=6.4u
M_d_1289 _n_467 _n_422 VSS VSS NMOS_mst L=1u W=3.4u AS=5.1p AD=5.1p PS=6.4u PD=6.4u
M_d_1290 BLp[2] _n_219 _n_467 VSS NMOS_mst L=1u W=3.4u AS=5.1p AD=9.52p PS=6.4u PD=12.4u
M_d_1291 _n_423 _n_220 BLn[2] VSS NMOS_mst L=1u W=3.4u AS=9.52p AD=5.1p PS=12.4u PD=6.4u
M_d_1292 VSS _n_447 _n_423 VSS NMOS_mst L=1u W=3.4u AS=5.1p AD=5.1p PS=6.4u PD=6.4u
M_d_1293 _n_447 _n_423 VSS VSS NMOS_mst L=1u W=3.4u AS=5.1p AD=5.1p PS=6.4u PD=6.4u
M_d_1294 BLp[2] _n_220 _n_447 VSS NMOS_mst L=1u W=3.4u AS=5.1p AD=9.52p PS=6.4u PD=12.4u
M_d_1295 _n_472 LATp VSS VSS NMOS_mst L=1u W=10.8u AS=23.22p AD=23.22p PS=24.8u PD=24.8u
M_d_1297 _n_454 BLn[2] _n_432 VSS NMOS_mst L=1u W=5.4u AS=15.075p AD=3.24p PS=16.224u PD=6.6u
M_d_1298 _n_472 _n_473 _n_454 VSS NMOS_mst L=1u W=5.4u AS=3.24p AD=8.1p PS=6.6u PD=8.4u
M_d_1299 _n_477 _n_432 _n_472 VSS NMOS_mst L=1u W=5.4u AS=8.1p AD=3.24p PS=8.4u PD=6.6u
M_d_1300 _n_473 BLp[2] _n_477 VSS NMOS_mst L=1u W=5.4u AS=3.24p AD=15.075p PS=6.6u PD=16.224u
M_d_1301 _n_472 _n_473 _n_432 VSS NMOS_mst L=1u W=3.4u AS=9.52p AD=5.1p PS=12.4u PD=6.4u
M_d_1302 _n_473 _n_432 _n_472 VSS NMOS_mst L=1u W=3.4u AS=5.1p AD=9.52p PS=6.4u PD=12.4u
M_d_1303 VSS _n_435 _n_398 VSS NMOS_mst L=1u W=3.4u AS=9.52p AD=5.1p PS=12.4u PD=6.4u
M_d_1304 _n_435 DIN[2] VSS VSS NMOS_mst L=1u W=3.4u AS=5.1p AD=9.52p PS=6.4u PD=12.4u
M_d_1305 _n_480 _n_197 BLn[3] VSS NMOS_mst L=1u W=3.4u AS=9.52p AD=5.1p PS=12.4u PD=6.4u
M_d_1306 VSS _n_536 _n_480 VSS NMOS_mst L=1u W=3.4u AS=5.1p AD=5.1p PS=6.4u PD=6.4u
M_d_1307 _n_536 _n_480 VSS VSS NMOS_mst L=1u W=3.4u AS=5.1p AD=5.1p PS=6.4u PD=6.4u
M_d_1308 BLp[3] _n_197 _n_536 VSS NMOS_mst L=1u W=3.4u AS=5.1p AD=9.52p PS=6.4u PD=12.4u
M_d_1309 _n_481 _n_198 BLn[3] VSS NMOS_mst L=1u W=3.4u AS=9.52p AD=5.1p PS=12.4u PD=6.4u
M_d_1310 VSS _n_516 _n_481 VSS NMOS_mst L=1u W=3.4u AS=5.1p AD=5.1p PS=6.4u PD=6.4u
M_d_1311 _n_516 _n_481 VSS VSS NMOS_mst L=1u W=3.4u AS=5.1p AD=5.1p PS=6.4u PD=6.4u
M_d_1312 BLp[3] _n_198 _n_516 VSS NMOS_mst L=1u W=3.4u AS=5.1p AD=9.52p PS=6.4u PD=12.4u
M_d_1313 _n_482 _n_199 BLn[3] VSS NMOS_mst L=1u W=3.4u AS=9.52p AD=5.1p PS=12.4u PD=6.4u
M_d_1314 VSS _n_537 _n_482 VSS NMOS_mst L=1u W=3.4u AS=5.1p AD=5.1p PS=6.4u PD=6.4u
M_d_1315 _n_537 _n_482 VSS VSS NMOS_mst L=1u W=3.4u AS=5.1p AD=5.1p PS=6.4u PD=6.4u
M_d_1316 BLp[3] _n_199 _n_537 VSS NMOS_mst L=1u W=3.4u AS=5.1p AD=9.52p PS=6.4u PD=12.4u
M_d_1317 _n_483 _n_200 BLn[3] VSS NMOS_mst L=1u W=3.4u AS=9.52p AD=5.1p PS=12.4u PD=6.4u
M_d_1318 VSS _n_517 _n_483 VSS NMOS_mst L=1u W=3.4u AS=5.1p AD=5.1p PS=6.4u PD=6.4u
M_d_1319 _n_517 _n_483 VSS VSS NMOS_mst L=1u W=3.4u AS=5.1p AD=5.1p PS=6.4u PD=6.4u
M_d_1320 BLp[3] _n_200 _n_517 VSS NMOS_mst L=1u W=3.4u AS=5.1p AD=9.52p PS=6.4u PD=12.4u
M_d_1321 _n_484 _n_201 BLn[3] VSS NMOS_mst L=1u W=3.4u AS=9.52p AD=5.1p PS=12.4u PD=6.4u
M_d_1322 VSS _n_538 _n_484 VSS NMOS_mst L=1u W=3.4u AS=5.1p AD=5.1p PS=6.4u PD=6.4u
M_d_1323 _n_538 _n_484 VSS VSS NMOS_mst L=1u W=3.4u AS=5.1p AD=5.1p PS=6.4u PD=6.4u
M_d_1324 BLp[3] _n_201 _n_538 VSS NMOS_mst L=1u W=3.4u AS=5.1p AD=9.52p PS=6.4u PD=12.4u
M_d_1325 _n_486 _n_203 BLn[3] VSS NMOS_mst L=1u W=3.4u AS=9.52p AD=5.1p PS=12.4u PD=6.4u
M_d_1326 VSS _n_539 _n_486 VSS NMOS_mst L=1u W=3.4u AS=5.1p AD=5.1p PS=6.4u PD=6.4u
M_d_1327 _n_539 _n_486 VSS VSS NMOS_mst L=1u W=3.4u AS=5.1p AD=5.1p PS=6.4u PD=6.4u
M_d_1328 BLp[3] _n_203 _n_539 VSS NMOS_mst L=1u W=3.4u AS=5.1p AD=9.52p PS=6.4u PD=12.4u
M_d_1329 _n_487 _n_204 BLn[3] VSS NMOS_mst L=1u W=3.4u AS=9.52p AD=5.1p PS=12.4u PD=6.4u
M_d_1330 VSS _n_519 _n_487 VSS NMOS_mst L=1u W=3.4u AS=5.1p AD=5.1p PS=6.4u PD=6.4u
M_d_1331 _n_519 _n_487 VSS VSS NMOS_mst L=1u W=3.4u AS=5.1p AD=5.1p PS=6.4u PD=6.4u
M_d_1332 BLp[3] _n_204 _n_519 VSS NMOS_mst L=1u W=3.4u AS=5.1p AD=9.52p PS=6.4u PD=12.4u
M_d_1333 _n_488 _n_205 BLn[3] VSS NMOS_mst L=1u W=3.4u AS=9.52p AD=5.1p PS=12.4u PD=6.4u
M_d_1334 VSS _n_540 _n_488 VSS NMOS_mst L=1u W=3.4u AS=5.1p AD=5.1p PS=6.4u PD=6.4u
M_d_1335 _n_540 _n_488 VSS VSS NMOS_mst L=1u W=3.4u AS=5.1p AD=5.1p PS=6.4u PD=6.4u
M_d_1336 BLp[3] _n_205 _n_540 VSS NMOS_mst L=1u W=3.4u AS=5.1p AD=9.52p PS=6.4u PD=12.4u
M_d_1337 _n_489 _n_206 BLn[3] VSS NMOS_mst L=1u W=3.4u AS=9.52p AD=5.1p PS=12.4u PD=6.4u
M_d_1338 VSS _n_520 _n_489 VSS NMOS_mst L=1u W=3.4u AS=5.1p AD=5.1p PS=6.4u PD=6.4u
M_d_1339 _n_520 _n_489 VSS VSS NMOS_mst L=1u W=3.4u AS=5.1p AD=5.1p PS=6.4u PD=6.4u
M_d_1340 BLp[3] _n_206 _n_520 VSS NMOS_mst L=1u W=3.4u AS=5.1p AD=9.52p PS=6.4u PD=12.4u
M_d_1341 _n_491 _n_208 BLn[3] VSS NMOS_mst L=1u W=3.4u AS=9.52p AD=5.1p PS=12.4u PD=6.4u
M_d_1342 VSS _n_521 _n_491 VSS NMOS_mst L=1u W=3.4u AS=5.1p AD=5.1p PS=6.4u PD=6.4u
M_d_1343 _n_521 _n_491 VSS VSS NMOS_mst L=1u W=3.4u AS=5.1p AD=5.1p PS=6.4u PD=6.4u
M_d_1344 BLp[3] _n_208 _n_521 VSS NMOS_mst L=1u W=3.4u AS=5.1p AD=9.52p PS=6.4u PD=12.4u
M_d_1345 _n_492 _n_209 BLn[3] VSS NMOS_mst L=1u W=3.4u AS=9.52p AD=5.1p PS=12.4u PD=6.4u
M_d_1346 VSS _n_542 _n_492 VSS NMOS_mst L=1u W=3.4u AS=5.1p AD=5.1p PS=6.4u PD=6.4u
M_d_1347 _n_542 _n_492 VSS VSS NMOS_mst L=1u W=3.4u AS=5.1p AD=5.1p PS=6.4u PD=6.4u
M_d_1348 BLp[3] _n_209 _n_542 VSS NMOS_mst L=1u W=3.4u AS=5.1p AD=9.52p PS=6.4u PD=12.4u
M_d_1349 _n_494 _n_211 BLn[3] VSS NMOS_mst L=1u W=3.4u AS=9.52p AD=5.1p PS=12.4u PD=6.4u
M_d_1350 VSS _n_543 _n_494 VSS NMOS_mst L=1u W=3.4u AS=5.1p AD=5.1p PS=6.4u PD=6.4u
M_d_1351 _n_543 _n_494 VSS VSS NMOS_mst L=1u W=3.4u AS=5.1p AD=5.1p PS=6.4u PD=6.4u
M_d_1352 BLp[3] _n_211 _n_543 VSS NMOS_mst L=1u W=3.4u AS=5.1p AD=9.52p PS=6.4u PD=12.4u
M_d_1353 _n_495 _n_212 BLn[3] VSS NMOS_mst L=1u W=3.4u AS=9.52p AD=5.1p PS=12.4u PD=6.4u
M_d_1354 VSS _n_523 _n_495 VSS NMOS_mst L=1u W=3.4u AS=5.1p AD=5.1p PS=6.4u PD=6.4u
M_d_1355 _n_523 _n_495 VSS VSS NMOS_mst L=1u W=3.4u AS=5.1p AD=5.1p PS=6.4u PD=6.4u
M_d_1356 BLp[3] _n_212 _n_523 VSS NMOS_mst L=1u W=3.4u AS=5.1p AD=9.52p PS=6.4u PD=12.4u
M_d_1357 _n_496 _n_213 BLn[3] VSS NMOS_mst L=1u W=3.4u AS=9.52p AD=5.1p PS=12.4u PD=6.4u
M_d_1358 VSS _n_544 _n_496 VSS NMOS_mst L=1u W=3.4u AS=5.1p AD=5.1p PS=6.4u PD=6.4u
M_d_1359 _n_544 _n_496 VSS VSS NMOS_mst L=1u W=3.4u AS=5.1p AD=5.1p PS=6.4u PD=6.4u
M_d_1360 BLp[3] _n_213 _n_544 VSS NMOS_mst L=1u W=3.4u AS=5.1p AD=9.52p PS=6.4u PD=12.4u
M_d_1361 _n_498 _n_215 BLn[3] VSS NMOS_mst L=1u W=3.4u AS=9.52p AD=5.1p PS=12.4u PD=6.4u
M_d_1362 VSS _n_545 _n_498 VSS NMOS_mst L=1u W=3.4u AS=5.1p AD=5.1p PS=6.4u PD=6.4u
M_d_1363 _n_545 _n_498 VSS VSS NMOS_mst L=1u W=3.4u AS=5.1p AD=5.1p PS=6.4u PD=6.4u
M_d_1364 BLp[3] _n_215 _n_545 VSS NMOS_mst L=1u W=3.4u AS=5.1p AD=9.52p PS=6.4u PD=12.4u
M_d_1365 _n_499 _n_216 BLn[3] VSS NMOS_mst L=1u W=3.4u AS=9.52p AD=5.1p PS=12.4u PD=6.4u
M_d_1366 VSS _n_525 _n_499 VSS NMOS_mst L=1u W=3.4u AS=5.1p AD=5.1p PS=6.4u PD=6.4u
M_d_1367 _n_525 _n_499 VSS VSS NMOS_mst L=1u W=3.4u AS=5.1p AD=5.1p PS=6.4u PD=6.4u
M_d_1368 BLp[3] _n_216 _n_525 VSS NMOS_mst L=1u W=3.4u AS=5.1p AD=9.52p PS=6.4u PD=12.4u
M_d_1369 _n_500 _n_217 BLn[3] VSS NMOS_mst L=1u W=3.4u AS=9.52p AD=5.1p PS=12.4u PD=6.4u
M_d_1370 VSS _n_546 _n_500 VSS NMOS_mst L=1u W=3.4u AS=5.1p AD=5.1p PS=6.4u PD=6.4u
M_d_1371 _n_546 _n_500 VSS VSS NMOS_mst L=1u W=3.4u AS=5.1p AD=5.1p PS=6.4u PD=6.4u
M_d_1372 BLp[3] _n_217 _n_546 VSS NMOS_mst L=1u W=3.4u AS=5.1p AD=9.52p PS=6.4u PD=12.4u
M_d_1373 _n_501 _n_218 BLn[3] VSS NMOS_mst L=1u W=3.4u AS=9.52p AD=5.1p PS=12.4u PD=6.4u
M_d_1374 VSS _n_526 _n_501 VSS NMOS_mst L=1u W=3.4u AS=5.1p AD=5.1p PS=6.4u PD=6.4u
M_d_1375 _n_526 _n_501 VSS VSS NMOS_mst L=1u W=3.4u AS=5.1p AD=5.1p PS=6.4u PD=6.4u
M_d_1376 BLp[3] _n_218 _n_526 VSS NMOS_mst L=1u W=3.4u AS=5.1p AD=9.52p PS=6.4u PD=12.4u
M_d_1377 _n_502 _n_219 BLn[3] VSS NMOS_mst L=1u W=3.4u AS=9.52p AD=5.1p PS=12.4u PD=6.4u
M_d_1378 VSS _n_547 _n_502 VSS NMOS_mst L=1u W=3.4u AS=5.1p AD=5.1p PS=6.4u PD=6.4u
M_d_1379 _n_547 _n_502 VSS VSS NMOS_mst L=1u W=3.4u AS=5.1p AD=5.1p PS=6.4u PD=6.4u
M_d_1380 BLp[3] _n_219 _n_547 VSS NMOS_mst L=1u W=3.4u AS=5.1p AD=9.52p PS=6.4u PD=12.4u
M_d_1381 _n_503 _n_220 BLn[3] VSS NMOS_mst L=1u W=3.4u AS=9.52p AD=5.1p PS=12.4u PD=6.4u
M_d_1382 VSS _n_527 _n_503 VSS NMOS_mst L=1u W=3.4u AS=5.1p AD=5.1p PS=6.4u PD=6.4u
M_d_1383 _n_527 _n_503 VSS VSS NMOS_mst L=1u W=3.4u AS=5.1p AD=5.1p PS=6.4u PD=6.4u
M_d_1384 BLp[3] _n_220 _n_527 VSS NMOS_mst L=1u W=3.4u AS=5.1p AD=9.52p PS=6.4u PD=12.4u
M_d_1385 _n_504 _n_221 BLn[3] VSS NMOS_mst L=1u W=3.4u AS=9.52p AD=5.1p PS=12.4u PD=6.4u
M_d_1386 VSS _n_548 _n_504 VSS NMOS_mst L=1u W=3.4u AS=5.1p AD=5.1p PS=6.4u PD=6.4u
M_d_1387 _n_548 _n_504 VSS VSS NMOS_mst L=1u W=3.4u AS=5.1p AD=5.1p PS=6.4u PD=6.4u
M_d_1388 BLp[3] _n_221 _n_548 VSS NMOS_mst L=1u W=3.4u AS=5.1p AD=9.52p PS=6.4u PD=12.4u
M_d_1389 _n_505 _n_222 BLn[3] VSS NMOS_mst L=1u W=3.4u AS=9.52p AD=5.1p PS=12.4u PD=6.4u
M_d_1390 VSS _n_528 _n_505 VSS NMOS_mst L=1u W=3.4u AS=5.1p AD=5.1p PS=6.4u PD=6.4u
M_d_1391 _n_528 _n_505 VSS VSS NMOS_mst L=1u W=3.4u AS=5.1p AD=5.1p PS=6.4u PD=6.4u
M_d_1392 BLp[3] _n_222 _n_528 VSS NMOS_mst L=1u W=3.4u AS=5.1p AD=9.52p PS=6.4u PD=12.4u
M_d_1393 _n_506 _n_223 BLn[3] VSS NMOS_mst L=1u W=3.4u AS=9.52p AD=5.1p PS=12.4u PD=6.4u
M_d_1394 VSS _n_549 _n_506 VSS NMOS_mst L=1u W=3.4u AS=5.1p AD=5.1p PS=6.4u PD=6.4u
M_d_1395 _n_549 _n_506 VSS VSS NMOS_mst L=1u W=3.4u AS=5.1p AD=5.1p PS=6.4u PD=6.4u
M_d_1396 BLp[3] _n_223 _n_549 VSS NMOS_mst L=1u W=3.4u AS=5.1p AD=9.52p PS=6.4u PD=12.4u
M_d_1397 _n_507 _n_224 BLn[3] VSS NMOS_mst L=1u W=3.4u AS=9.52p AD=5.1p PS=12.4u PD=6.4u
M_d_1398 VSS _n_529 _n_507 VSS NMOS_mst L=1u W=3.4u AS=5.1p AD=5.1p PS=6.4u PD=6.4u
M_d_1399 _n_529 _n_507 VSS VSS NMOS_mst L=1u W=3.4u AS=5.1p AD=5.1p PS=6.4u PD=6.4u
M_d_1400 BLp[3] _n_224 _n_529 VSS NMOS_mst L=1u W=3.4u AS=5.1p AD=9.52p PS=6.4u PD=12.4u
M_d_1401 _n_508 _n_225 BLn[3] VSS NMOS_mst L=1u W=3.4u AS=9.52p AD=5.1p PS=12.4u PD=6.4u
M_d_1402 VSS _n_550 _n_508 VSS NMOS_mst L=1u W=3.4u AS=5.1p AD=5.1p PS=6.4u PD=6.4u
M_d_1403 _n_550 _n_508 VSS VSS NMOS_mst L=1u W=3.4u AS=5.1p AD=5.1p PS=6.4u PD=6.4u
M_d_1404 BLp[3] _n_225 _n_550 VSS NMOS_mst L=1u W=3.4u AS=5.1p AD=9.52p PS=6.4u PD=12.4u
M_d_1405 _n_511 _n_228 BLn[3] VSS NMOS_mst L=1u W=3.4u AS=9.52p AD=5.1p PS=12.4u PD=6.4u
M_d_1406 VSS _n_531 _n_511 VSS NMOS_mst L=1u W=3.4u AS=5.1p AD=5.1p PS=6.4u PD=6.4u
M_d_1407 _n_531 _n_511 VSS VSS NMOS_mst L=1u W=3.4u AS=5.1p AD=5.1p PS=6.4u PD=6.4u
M_d_1408 BLp[3] _n_228 _n_531 VSS NMOS_mst L=1u W=3.4u AS=5.1p AD=9.52p PS=6.4u PD=12.4u
M_d_1409 _n_513 _n_512 VSS VSS NMOS_mst L=1u W=6.8u AS=14.62p AD=10.2p PS=18.8u PD=12.8u
M_d_1411 DO[3] _n_553 VSS VSS NMOS_mst L=1u W=6.8u AS=10.2p AD=14.62p PS=12.8u PD=18.8u
M_d_1413 _n_533 WRp BLn[3] VSS NMOS_mst L=1u W=5.4u AS=15.12p AD=3.24p PS=16.4u PD=6.6u
M_d_1414 VSS _n_478 _n_533 VSS NMOS_mst L=1u W=5.4u AS=3.24p AD=8.1p PS=6.6u PD=8.4u
M_d_1415 _n_556 _n_515 VSS VSS NMOS_mst L=1u W=5.4u AS=8.1p AD=3.24p PS=8.4u PD=6.6u
M_d_1416 BLp[3] WRp _n_556 VSS NMOS_mst L=1u W=5.4u AS=3.24p AD=15.12p PS=6.6u PD=16.4u
M_d_1417 _n_485 _n_202 BLn[3] VSS NMOS_mst L=1u W=3.4u AS=9.52p AD=5.1p PS=12.4u PD=6.4u
M_d_1418 VSS _n_518 _n_485 VSS NMOS_mst L=1u W=3.4u AS=5.1p AD=5.1p PS=6.4u PD=6.4u
M_d_1419 _n_518 _n_485 VSS VSS NMOS_mst L=1u W=3.4u AS=5.1p AD=5.1p PS=6.4u PD=6.4u
M_d_1420 BLp[3] _n_202 _n_518 VSS NMOS_mst L=1u W=3.4u AS=5.1p AD=9.52p PS=6.4u PD=12.4u
M_d_1421 _n_490 _n_207 BLn[3] VSS NMOS_mst L=1u W=3.4u AS=9.52p AD=5.1p PS=12.4u PD=6.4u
M_d_1422 VSS _n_541 _n_490 VSS NMOS_mst L=1u W=3.4u AS=5.1p AD=5.1p PS=6.4u PD=6.4u
M_d_1423 _n_541 _n_490 VSS VSS NMOS_mst L=1u W=3.4u AS=5.1p AD=5.1p PS=6.4u PD=6.4u
M_d_1424 BLp[3] _n_207 _n_541 VSS NMOS_mst L=1u W=3.4u AS=5.1p AD=9.52p PS=6.4u PD=12.4u
M_d_1425 _n_493 _n_210 BLn[3] VSS NMOS_mst L=1u W=3.4u AS=9.52p AD=5.1p PS=12.4u PD=6.4u
M_d_1426 VSS _n_522 _n_493 VSS NMOS_mst L=1u W=3.4u AS=5.1p AD=5.1p PS=6.4u PD=6.4u
M_d_1427 _n_522 _n_493 VSS VSS NMOS_mst L=1u W=3.4u AS=5.1p AD=5.1p PS=6.4u PD=6.4u
M_d_1428 BLp[3] _n_210 _n_522 VSS NMOS_mst L=1u W=3.4u AS=5.1p AD=9.52p PS=6.4u PD=12.4u
M_d_1429 _n_497 _n_214 BLn[3] VSS NMOS_mst L=1u W=3.4u AS=9.52p AD=5.1p PS=12.4u PD=6.4u
M_d_1430 VSS _n_524 _n_497 VSS NMOS_mst L=1u W=3.4u AS=5.1p AD=5.1p PS=6.4u PD=6.4u
M_d_1431 _n_524 _n_497 VSS VSS NMOS_mst L=1u W=3.4u AS=5.1p AD=5.1p PS=6.4u PD=6.4u
M_d_1432 BLp[3] _n_214 _n_524 VSS NMOS_mst L=1u W=3.4u AS=5.1p AD=9.52p PS=6.4u PD=12.4u
M_d_1433 _n_509 _n_226 BLn[3] VSS NMOS_mst L=1u W=3.4u AS=9.52p AD=5.1p PS=12.4u PD=6.4u
M_d_1434 VSS _n_530 _n_509 VSS NMOS_mst L=1u W=3.4u AS=5.1p AD=5.1p PS=6.4u PD=6.4u
M_d_1435 _n_530 _n_509 VSS VSS NMOS_mst L=1u W=3.4u AS=5.1p AD=5.1p PS=6.4u PD=6.4u
M_d_1436 BLp[3] _n_226 _n_530 VSS NMOS_mst L=1u W=3.4u AS=5.1p AD=9.52p PS=6.4u PD=12.4u
M_d_1437 _n_510 _n_227 BLn[3] VSS NMOS_mst L=1u W=3.4u AS=9.52p AD=5.1p PS=12.4u PD=6.4u
M_d_1438 VSS _n_551 _n_510 VSS NMOS_mst L=1u W=3.4u AS=5.1p AD=5.1p PS=6.4u PD=6.4u
M_d_1439 _n_551 _n_510 VSS VSS NMOS_mst L=1u W=3.4u AS=5.1p AD=5.1p PS=6.4u PD=6.4u
M_d_1440 BLp[3] _n_227 _n_551 VSS NMOS_mst L=1u W=3.4u AS=5.1p AD=9.52p PS=6.4u PD=12.4u
M_d_1441 _n_552 LATp VSS VSS NMOS_mst L=1u W=10.8u AS=23.22p AD=23.22p PS=24.8u PD=24.8u
M_d_1443 _n_534 BLn[3] _n_512 VSS NMOS_mst L=1u W=5.4u AS=15.075p AD=3.24p PS=16.224u PD=6.6u
M_d_1444 _n_552 _n_553 _n_534 VSS NMOS_mst L=1u W=5.4u AS=3.24p AD=8.1p PS=6.6u PD=8.4u
M_d_1445 _n_557 _n_512 _n_552 VSS NMOS_mst L=1u W=5.4u AS=8.1p AD=3.24p PS=8.4u PD=6.6u
M_d_1446 _n_553 BLp[3] _n_557 VSS NMOS_mst L=1u W=5.4u AS=3.24p AD=15.075p PS=6.6u PD=16.224u
M_d_1447 _n_552 _n_553 _n_512 VSS NMOS_mst L=1u W=3.4u AS=9.52p AD=5.1p PS=12.4u PD=6.4u
M_d_1448 _n_553 _n_512 _n_552 VSS NMOS_mst L=1u W=3.4u AS=5.1p AD=9.52p PS=6.4u PD=12.4u
M_d_1449 VSS _n_515 _n_478 VSS NMOS_mst L=1u W=3.4u AS=9.52p AD=5.1p PS=12.4u PD=6.4u
M_d_1450 _n_515 DIN[3] VSS VSS NMOS_mst L=1u W=3.4u AS=5.1p AD=9.52p PS=6.4u PD=12.4u
.ENDS SRAM128
.SUBCKT FILL3 vdd vss
M_d_1 vdd vss vdd vdd PMOS_mst L=8.6u W=15.8u AS=44.24p AD=44.24p PS=37.2u PD=37.2u
M_d_2 vss vdd vss vss NMOS_mst L=8.6u W=13.1u AS=36.68p AD=36.68p PS=31.8u PD=31.8u
.ENDS FILL3
.SUBCKT MUXDFFRB S QB A B CK RSTB Q vdd vss
M_d_1 Q QB vdd vdd PMOS_mst L=1u W=10.4u AS=29.12p AD=29.12p PS=32u PD=32u
M_d_2 QB QS vdd vdd PMOS_mst L=1u W=10.4u AS=27.56p AD=15.6p PS=26.2u PD=16.4u
M_d_3 vdd RSTB QB vdd PMOS_mst L=1u W=10.4u AS=15.6p AD=29.12p PS=16.4u PD=32u
M_d_4 _n_13 _n_10 vdd vdd PMOS_mst L=1u W=11.2u AS=31.36p AD=31.36p PS=28u PD=28u
M_d_5 vdd CK CKB vdd PMOS_mst L=1u W=10.4u AS=29.12p AD=15.6p PS=26.4u PD=13.4u
M_d_6 CKP CKB vdd vdd PMOS_mst L=1u W=10.4u AS=15.6p AD=29.12p PS=13.4u PD=26.4u
M_d_8 _n_24 _n_13 vdd vdd PMOS_mst L=1u W=5.2u AS=14.56p AD=3.12p PS=16u PD=6.4u
M_d_9 _n_15 CKP _n_24 vdd PMOS_mst L=1u W=5.2u AS=3.12p AD=7.8p PS=6.4u PD=8.2u
M_d_10 _n_16 CKB _n_15 vdd PMOS_mst L=1u W=5.2u AS=7.8p AD=7.8p PS=8.2u PD=8.2u
M_d_11 vdd QM _n_16 vdd PMOS_mst L=1u W=5.2u AS=7.8p AD=7.8p PS=8.2u PD=8.2u
M_d_12 QM _n_15 vdd vdd PMOS_mst L=1u W=5.2u AS=7.8p AD=7.8p PS=8.2u PD=8.2u
M_d_13 QS CKB QM vdd PMOS_mst L=1u W=5.2u AS=7.8p AD=7.8p PS=8.2u PD=8.2u
M_d_14 _n_18 CKP QS vdd PMOS_mst L=1u W=5.2u AS=7.8p AD=7.8p PS=8.2u PD=8.2u
M_d_15 vdd QB _n_18 vdd PMOS_mst L=1u W=5.2u AS=7.8p AD=13p PS=8.2u PD=10.2u
M_d_18 _n_2 S vdd vdd PMOS_mst L=1u W=5.2u AS=14.56p AD=14.56p PS=16u PD=16u
M_d_19 _n_9 A vdd vdd PMOS_mst L=1u W=5.2u AS=14.56p AD=7.8p PS=16u PD=8.2u
M_d_20 _n_10 S _n_9 vdd PMOS_mst L=1u W=5.2u AS=7.8p AD=7.8p PS=8.2u PD=8.2u
M_d_21 _n_11 _n_2 _n_10 vdd PMOS_mst L=1u W=5.2u AS=7.8p AD=7.8p PS=8.2u PD=8.2u
M_d_22 vdd B _n_11 vdd PMOS_mst L=1u W=5.2u AS=7.8p AD=15.6p PS=8.2u PD=16.4u
M_d_23 Q QB vss vss NMOS_mst L=1u W=3.4u AS=9.52p AD=9.52p PS=12.4u PD=12.4u
M_d_24 _n_22 _n_13 vss vss NMOS_mst L=1u W=3.4u AS=9.52p AD=2.04p PS=12.4u PD=4.6u
M_d_25 _n_15 CKB _n_22 vss NMOS_mst L=1u W=3.4u AS=2.04p AD=5.1p PS=4.6u PD=6.4u
M_d_26 _n_16 CKP _n_15 vss NMOS_mst L=1u W=3.4u AS=5.1p AD=5.1p PS=6.4u PD=6.4u
M_d_27 vss QM _n_16 vss NMOS_mst L=1u W=3.4u AS=5.1p AD=5.1p PS=6.4u PD=6.4u
M_d_28 QM _n_15 vss vss NMOS_mst L=1u W=3.4u AS=5.1p AD=5.1p PS=6.4u PD=6.4u
M_d_29 QS CKP QM vss NMOS_mst L=1u W=3.4u AS=5.1p AD=5.1p PS=6.4u PD=6.4u
M_d_30 _n_18 CKB QS vss NMOS_mst L=1u W=3.4u AS=5.1p AD=5.1p PS=6.4u PD=6.4u
M_d_31 vss QB _n_18 vss NMOS_mst L=1u W=3.4u AS=5.1p AD=8.5p PS=6.4u PD=8.4u
M_d_32 _n_21 QS vss vss NMOS_mst L=1u W=3.4u AS=8.5p AD=2.21p PS=8.4u PD=4.7u
M_d_33 QB RSTB _n_21 vss NMOS_mst L=1u W=3.4u AS=2.21p AD=9.52p PS=4.7u PD=12.4u
M_d_34 vss CK CKB vss NMOS_mst L=1u W=3.4u AS=9.52p AD=5.1p PS=12.4u PD=6.4u
M_d_35 CKP CKB vss vss NMOS_mst L=1u W=3.4u AS=5.1p AD=9.52p PS=6.4u PD=12.4u
M_d_36 _n_9 A vss vss NMOS_mst L=1u W=3.4u AS=9.52p AD=5.1p PS=12.4u PD=6.4u
M_d_37 _n_10 _n_2 _n_9 vss NMOS_mst L=1u W=3.4u AS=5.1p AD=5.1p PS=6.4u PD=6.4u
M_d_38 _n_11 S _n_10 vss NMOS_mst L=1u W=3.4u AS=5.1p AD=5.1p PS=6.4u PD=6.4u
M_d_39 vss B _n_11 vss NMOS_mst L=1u W=3.4u AS=5.1p AD=9.52p PS=6.4u PD=12.4u
M_d_40 _n_13 _n_10 vss vss NMOS_mst L=1u W=3.4u AS=9.52p AD=9.52p PS=12.4u PD=12.4u
M_d_41 _n_2 S vss vss NMOS_mst L=1u W=3.4u AS=10.2p AD=9.52p PS=12.8u PD=12.4u
.ENDS MUXDFFRB
.SUBCKT DFFRB QB D RSTB Q vdd CK vss
M_d_1 Q QB vdd vdd PMOS_mst L=1u W=10.4u AS=29.12p AD=29.12p PS=32u PD=32u
M_d_3 vdd CK CKB vdd PMOS_mst L=1u W=10.4u AS=29.12p AD=15.6p PS=26.4u PD=13.4u
M_d_4 CKP CKB vdd vdd PMOS_mst L=1u W=10.4u AS=15.6p AD=29.12p PS=13.4u PD=26.4u
M_d_5 _n_16 D vdd vdd PMOS_mst L=1u W=5.2u AS=14.56p AD=3.12p PS=16u PD=6.4u
M_d_6 _n_7 CKP _n_16 vdd PMOS_mst L=1u W=5.2u AS=3.12p AD=7.8p PS=6.4u PD=8.2u
M_d_7 _n_8 CKB _n_7 vdd PMOS_mst L=1u W=5.2u AS=7.8p AD=7.8p PS=8.2u PD=8.2u
M_d_8 vdd QM _n_8 vdd PMOS_mst L=1u W=5.2u AS=7.8p AD=7.8p PS=8.2u PD=8.2u
M_d_9 QM _n_7 vdd vdd PMOS_mst L=1u W=5.2u AS=7.8p AD=7.8p PS=8.2u PD=8.2u
M_d_10 QS CKB QM vdd PMOS_mst L=1u W=5.2u AS=7.8p AD=7.8p PS=8.2u PD=8.2u
M_d_11 _n_10 CKP QS vdd PMOS_mst L=1u W=5.2u AS=7.8p AD=7.8p PS=8.2u PD=8.2u
M_d_12 vdd QB _n_10 vdd PMOS_mst L=1u W=5.2u AS=7.8p AD=13p PS=8.2u PD=10.2u
M_d_13 QB QS vdd vdd PMOS_mst L=1u W=10.4u AS=27.56p AD=15.6p PS=26.2u PD=16.4u
M_d_14 vdd RSTB QB vdd PMOS_mst L=1u W=10.4u AS=15.6p AD=29.12p PS=16.4u PD=32u
M_d_17 Q QB vss vss NMOS_mst L=1u W=3.4u AS=9.52p AD=9.52p PS=12.4u PD=12.4u
M_d_18 _n_13 D vss vss NMOS_mst L=1u W=3.4u AS=9.52p AD=2.04p PS=12.4u PD=4.6u
M_d_19 _n_7 CKB _n_13 vss NMOS_mst L=1u W=3.4u AS=2.04p AD=5.1p PS=4.6u PD=6.4u
M_d_20 _n_8 CKP _n_7 vss NMOS_mst L=1u W=3.4u AS=5.1p AD=5.1p PS=6.4u PD=6.4u
M_d_21 vss QM _n_8 vss NMOS_mst L=1u W=3.4u AS=5.1p AD=5.1p PS=6.4u PD=6.4u
M_d_22 QM _n_7 vss vss NMOS_mst L=1u W=3.4u AS=5.1p AD=5.1p PS=6.4u PD=6.4u
M_d_23 QS CKP QM vss NMOS_mst L=1u W=3.4u AS=5.1p AD=5.1p PS=6.4u PD=6.4u
M_d_24 _n_10 CKB QS vss NMOS_mst L=1u W=3.4u AS=5.1p AD=5.1p PS=6.4u PD=6.4u
M_d_25 vss QB _n_10 vss NMOS_mst L=1u W=3.4u AS=5.1p AD=8.5p PS=6.4u PD=8.4u
M_d_26 _n_14 QS vss vss NMOS_mst L=1u W=3.4u AS=8.5p AD=2.21p PS=8.4u PD=4.7u
M_d_27 QB RSTB _n_14 vss NMOS_mst L=1u W=3.4u AS=2.21p AD=9.52p PS=4.7u PD=12.4u
M_d_28 vss CK CKB vss NMOS_mst L=1u W=3.4u AS=9.52p AD=5.1p PS=12.4u PD=6.4u
M_d_29 CKP CKB vss vss NMOS_mst L=1u W=3.4u AS=5.1p AD=9.52p PS=6.4u PD=12.4u
.ENDS DFFRB
.SUBCKT AOI21 A1 B A2 Y vdd vss
M_d_1 Y B _n_7 vdd PMOS_mst L=1u W=10.2u AS=28.56p AD=28.56p PS=26u PD=26u
M_d_2 _n_7 A1 vdd vdd PMOS_mst L=1u W=10.2u AS=28.56p AD=15.3p PS=26u PD=13.2u
M_d_3 vdd A2 _n_7 vdd PMOS_mst L=1u W=10.2u AS=15.3p AD=28.56p PS=13.2u PD=26u
M_d_4 _n_8 A1 vss vss NMOS_mst L=1u W=3.4u AS=9.52p AD=2.04p PS=12.4u PD=4.6u
M_d_5 Y A2 _n_8 vss NMOS_mst L=1u W=3.4u AS=2.04p AD=5.1p PS=4.6u PD=6.4u
M_d_6 vss B Y vss NMOS_mst L=1u W=3.4u AS=5.1p AD=9.52p PS=6.4u PD=12.4u
.ENDS AOI21
.SUBCKT AOI22 A1 B1 A2 B2 vdd Y vss
M_d_1 Y B1 _n_5 vdd PMOS_mst L=1u W=10.2u AS=28.56p AD=15.3p PS=26u PD=13.2u
M_d_2 _n_5 B2 Y vdd PMOS_mst L=1u W=10.2u AS=15.3p AD=28.56p PS=13.2u PD=26u
M_d_3 _n_5 A1 vdd vdd PMOS_mst L=1u W=10.2u AS=28.56p AD=15.3p PS=26u PD=13.2u
M_d_4 vdd A2 _n_5 vdd PMOS_mst L=1u W=10.2u AS=15.3p AD=28.56p PS=13.2u PD=26u
M_d_5 _n_10 A1 vss vss NMOS_mst L=1u W=3.4u AS=9.52p AD=2.04p PS=12.4u PD=4.6u
M_d_6 Y A2 _n_10 vss NMOS_mst L=1u W=3.4u AS=2.04p AD=5.1p PS=4.6u PD=6.4u
M_d_7 _n_9 B1 Y vss NMOS_mst L=1u W=3.4u AS=5.1p AD=2.04p PS=6.4u PD=4.6u
M_d_8 vss B2 _n_9 vss NMOS_mst L=1u W=3.4u AS=2.04p AD=9.52p PS=4.6u PD=12.4u
.ENDS AOI22
.SUBCKT NAND3 A B C Y vdd vss
M_d_1 Y A vdd vdd PMOS_mst L=1u W=10.2u AS=28.56p AD=15.3p PS=26u PD=13.2u
M_d_2 vdd B Y vdd PMOS_mst L=1u W=10.2u AS=15.3p AD=15.3p PS=13.2u PD=13.2u
M_d_3 Y C vdd vdd PMOS_mst L=1u W=10.2u AS=15.3p AD=28.56p PS=13.2u PD=26u
M_d_4 _n_8 A vss vss NMOS_mst L=1u W=3.4u AS=9.52p AD=2.04p PS=12.4u PD=4.6u
M_d_5 _n_7 B _n_8 vss NMOS_mst L=1u W=3.4u AS=2.04p AD=2.04p PS=4.6u PD=4.6u
M_d_6 Y C _n_7 vss NMOS_mst L=1u W=3.4u AS=2.04p AD=9.52p PS=4.6u PD=12.4u
.ENDS NAND3
.SUBCKT AND3_X1 C A B Y vdd vss
M_d_1 Y _n_4 vdd vdd PMOS_mst L=1u W=10.2u AS=28.56p AD=28.56p PS=26u PD=26u
M_d_2 _n_4 A vdd vdd PMOS_mst L=1u W=10.2u AS=28.56p AD=15.3p PS=26u PD=13.2u
M_d_3 vdd B _n_4 vdd PMOS_mst L=1u W=10.2u AS=15.3p AD=15.3p PS=13.2u PD=13.2u
M_d_4 _n_4 C vdd vdd PMOS_mst L=1u W=10.2u AS=15.3p AD=28.56p PS=13.2u PD=26u
M_d_5 Y _n_4 vss vss NMOS_mst L=1u W=3.4u AS=9.52p AD=9.52p PS=12.4u PD=12.4u
M_d_6 _n_9 A vss vss NMOS_mst L=1u W=3.4u AS=9.52p AD=2.04p PS=12.4u PD=4.6u
M_d_7 _n_8 B _n_9 vss NMOS_mst L=1u W=3.4u AS=2.04p AD=2.04p PS=4.6u PD=4.6u
M_d_8 _n_4 C _n_8 vss NMOS_mst L=1u W=3.4u AS=2.04p AD=9.52p PS=4.6u PD=12.4u
.ENDS AND3_X1
.SUBCKT OAI21 B A1 A2 vdd Y vss
M_d_1 _n_8 A1 vdd vdd PMOS_mst L=1u W=10.2u AS=28.56p AD=6.12p PS=26u PD=11.4u
M_d_2 Y A2 _n_8 vdd PMOS_mst L=1u W=10.2u AS=6.12p AD=15.3p PS=11.4u PD=13.2u
M_d_3 vdd B Y vdd PMOS_mst L=1u W=10.2u AS=15.3p AD=28.56p PS=13.2u PD=26u
M_d_4 Y B _n_6 vss NMOS_mst L=1u W=3.4u AS=9.52p AD=9.52p PS=12.4u PD=12.4u
M_d_5 _n_6 A1 vss vss NMOS_mst L=1u W=3.4u AS=9.52p AD=5.1p PS=12.4u PD=6.4u
M_d_6 vss A2 _n_6 vss NMOS_mst L=1u W=3.4u AS=5.1p AD=9.52p PS=6.4u PD=12.4u
.ENDS OAI21
.SUBCKT OSS_NCH_ESD PAD VSS
M_d_1 VSS VSS PAD VSS MNE_mst L=2u W=50u M=10 AS=352.3p AD=352.3p PS=68.94u PD=68.94u
.ENDS OSS_NCH_ESD
.SUBCKT OSS_PCH_ESD PAD VDD
M_d_1 VDD VDD PAD VDD PMOS_mst L=2u W=50u M=10 AS=352.3p AD=352.3p PS=68.94u PD=68.94u
.ENDS OSS_PCH_ESD
.SUBCKT OSS_NCH_DRV PAD _n_14 VSS
M_d_1 VSS VSS PAD VSS MNE_mst L=2u W=50u M=7 AS=378.3p AD=310.7p PS=72.05u PD=62.43u
M_d_8 PAD _n_14 VSS VSS MNE_mst L=2u W=50u M=3 AS=291.7p AD=449.3p PS=61.67u PD=84.12u
.ENDS OSS_NCH_DRV
.SUBCKT OSS_PCH_DRV PAD VDD _n_3
M_d_1 VDD VDD PAD VDD PMOS_mst L=2u W=50u M=4 AS=393.3p AD=325p PS=77.84u PD=63u
M_d_5 VDD _n_3 PAD VDD PMOS_mst L=2u W=50u M=6 AS=325p AD=370.5p PS=63u PD=72.89u
.ENDS OSS_PCH_DRV
.SUBCKT OSS_DRV OUT HIZ vdd _n_16 _n_17 GND_gnd
M_d_1 _n_14 HIZ _n_12 vdd PMOS_mst L=1u W=10.4u AS=29.12p AD=6.24p PS=26.4u PD=11.6u
M_d_2 vdd _n_8 _n_14 vdd PMOS_mst L=1u W=10.4u AS=6.24p AD=26p PS=11.6u PD=15.4u
M_d_3 _n_16 _n_12 vdd vdd PMOS_mst L=1u W=20.8u AS=55.12p AD=58.24p PS=41.8u PD=52.8u
M_d_5 _n_17 _n_13 vdd vdd PMOS_mst L=1u W=20.8u AS=56.68p AD=58.24p PS=47u PD=52.8u
M_d_6 vdd HIZ _n_6 vdd PMOS_mst L=1u W=5.2u AS=14.56p AD=7.8p PS=16u PD=8.2u
M_d_7 _n_13 _n_6 vdd vdd PMOS_mst L=1u W=5.2u AS=7.8p AD=7.8p PS=8.2u PD=8.2u
M_d_8 vdd _n_8 _n_13 vdd PMOS_mst L=1u W=5.2u AS=7.8p AD=13p PS=8.2u PD=10.2u
M_d_10 vdd OUT _n_8 vdd PMOS_mst L=1u W=5.2u AS=14.56p AD=22.36p PS=16u PD=19u
M_d_11 GND_gnd OUT _n_8 GND_gnd NMOS_mst L=1u W=3.4u AS=9.52p AD=5.1p PS=12.4u PD=6.4u
M_d_12 _n_12 HIZ GND_gnd GND_gnd NMOS_mst L=1u W=3.4u AS=5.1p AD=5.1p PS=6.4u PD=6.4u
M_d_13 GND_gnd _n_8 _n_12 GND_gnd NMOS_mst L=1u W=3.4u AS=5.1p AD=8.5p PS=6.4u PD=8.4u
M_d_14 _n_16 _n_12 GND_gnd GND_gnd NMOS_mst L=1u W=6.8u AS=18.02p AD=19.04p PS=20.8u PD=24.8u
M_d_16 _n_15 _n_6 _n_13 GND_gnd NMOS_mst L=1u W=3.4u AS=9.52p AD=2.04p PS=12.4u PD=4.6u
M_d_17 GND_gnd _n_8 _n_15 GND_gnd NMOS_mst L=1u W=3.4u AS=2.04p AD=8.5p PS=4.6u PD=8.4u
M_d_18 _n_17 _n_13 GND_gnd GND_gnd NMOS_mst L=1u W=6.8u AS=18.02p AD=19.04p PS=20.8u PD=24.8u
M_d_20 GND_gnd HIZ _n_6 GND_gnd NMOS_mst L=1u W=3.4u AS=9.52p AD=9.52p PS=12.4u PD=12.4u
D_d_21 GND_gnd OUT DN AREA=12.96p PJ=14.4u
D_d_22 GND_gnd HIZ DN AREA=12.96p PJ=14.4u
.ENDS OSS_DRV
